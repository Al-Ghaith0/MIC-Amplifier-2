MIC amplifier
*SPICE Netlist generated by Advanced Sim server on 10/28/2024 2:33:23 PM

*Schematic Netlist:
CC1 NetC1_1 NetC1_2 10uF
CC2 NetC2_1 NetC2_2 10uF
CC3 NetC3_1 NetC3_2 10uF
CC4 NetC4_1 0 1pF
CC5 NetC5_1 0 1pF
QQ1 NetC3_2 NetC3_2 NetP1_1  GENERATED_MODEL_QQ1
QQ2 NetQ2_2 NetQ2_2 NetP1_1  GENERATED_MODEL_QQ2
QQ3 NetQ3_2 NetQ3_3 NetP1_1  GENERATED_MODEL_QQ3
QQ4 NetQ4_2 NetQ4_3 NetP1_1  GENERATED_MODEL_QQ4
QQ5 NetC3_1 NetQ3_3 NetP1_1  GENERATED_MODEL_QQ5
QQ6 NetQ6_1 Basep1 NetP1_1  GENERATED_MODEL_QQ6
QQ7 NetQ7_2 NetQ7_3 NetP1_1  GENERATED_MODEL_QQ7
QQ8 NetQ8_2 NetQ8_2 0  GENERATED_MODEL_QQ8
QQ9 NetQ4_2 NetQ8_2 0  GENERATED_MODEL_QQ9
QQ10 NetQ10_2 NetQ10_2 NetQ3_2  GENERATED_MODEL_QQ10
QQ11 0 NetQ11_3 NetC3_1  GENERATED_MODEL_QQ11
QQ12 NetQ10_2 Basen2 0  GENERATED_MODEL_QQ12
QQ13 NetQ13_1 Basep1 NetP1_1  GENERATED_MODEL_QQ13
QQ14 NetQ14_2 NetQ14_2 NetP1_1  GENERATED_MODEL_QQ14
QQ15 NetQ15_2 NetQ14_2 NetP1_1  GENERATED_MODEL_QQ15
QQ16 NetQ16_2 NetQ16_2 NetP1_1  GENERATED_MODEL_QQ16
QQ17 NetQ17_2 NetQ16_2 NetP1_1  GENERATED_MODEL_QQ17
QQ18 NetQ18_2 NetQ18_2 NetQ17_2  GENERATED_MODEL_QQ18
QQ19 NetQ19_2 NetQ19_2 NetQ14_2  GENERATED_MODEL_QQ19
QQ20 NetQ20_2 NetQ11_3 NetQ7_2  GENERATED_MODEL_QQ20
QQ21 0 NetQ18_2 NetQ15_2  GENERATED_MODEL_QQ21
QQ22 NetQ22_1 Basep1 NetP1_1  GENERATED_MODEL_QQ22
QQ23 NetQ7_3 NetQ7_3 NetP1_1  GENERATED_MODEL_QQ23
QQ24 NetQ7_3 Basen2 0  GENERATED_MODEL_QQ24
QQ26 NetQ22_1 NetQ22_1 0  GENERATED_MODEL_QQ26
QQ27 NetQ20_2 NetQ22_1 0  GENERATED_MODEL_QQ27
QQ28 NetQ16_2 Basen2 0  GENERATED_MODEL_QQ28
QQ29 NetQ19_2 Basen2 0  GENERATED_MODEL_QQ29
QQ30 NetQ13_1 NetQ13_1 0  GENERATED_MODEL_QQ30
QQ31 NetQ18_2 NetQ13_1 0  GENERATED_MODEL_QQ31
QQ32 NetQ6_1 NetQ6_1 0  GENERATED_MODEL_QQ32
QQ33 NetC3_2 NetQ6_1 0  GENERATED_MODEL_QQ33
QQ34 0 NetQ3_2 NetQ3_3  GENERATED_MODEL_QQ34
QQ35 0 NetQ20_2 NetQ11_3  GENERATED_MODEL_QQ35
QQ36 NetQ8_2 NetQ2_2 NetP1_1  GENERATED_MODEL_QQ36
QQ37 NetQ2_2 Basen2 0  GENERATED_MODEL_QQ37
QQ119 NetP3_1 NetQ119_3 NetP1_1  GENERATED_MODEL_QQ119
QQ120 NetQ120_2 NetQ120_3 NetP1_1  GENERATED_MODEL_QQ120
QQ121 NetQ121_2 NetQ121_3 NetP1_1  GENERATED_MODEL_QQ121
QQ122 NetP2_2 NetQ119_3 NetP1_1  GENERATED_MODEL_QQ122
QQ123 NetQ119_3 NetQ119_3 NetP1_1  GENERATED_MODEL_QQ123
QQ124 NetQ124_1 Basep1 NetP1_1  GENERATED_MODEL_QQ124
QQ125 NetQ125_1 Basep1 NetP1_1  GENERATED_MODEL_QQ125
QQ126 NetQ126_1 Basep1 NetP1_1  GENERATED_MODEL_QQ126
QQ127 NetQ127_2 NetQ121_3 NetP1_1  GENERATED_MODEL_QQ127
QQ128 NetQ128_2 NetQ121_3 NetP1_1  GENERATED_MODEL_QQ128
QQ129 NetQ128_2 NetQ121_3 NetP1_1  GENERATED_MODEL_QQ129
QQ130 NetQ130_2 NetQ130_3 NetP1_1  GENERATED_MODEL_QQ130
QQ131 NetQ130_2 NetQ130_3 NetP1_1  GENERATED_MODEL_QQ131
QQ132 0 NetQ125_1 Basep1  GENERATED_MODEL_QQ132
QQ133 NetQ133_2 NetQ133_3 NetP1_1  GENERATED_MODEL_QQ133
QQ134 NetQ133_2 NetQ133_3 NetP1_1  GENERATED_MODEL_QQ134
QQ135 0 NetQ128_2 NetQ121_3  GENERATED_MODEL_QQ135
QQ136 NetQ120_3 NetQ120_3 NetP1_1  GENERATED_MODEL_QQ136
QQ137 NetQ120_3 Basen2 0  GENERATED_MODEL_QQ137
QQ138 0 NetQ130_2 NetQ130_3  GENERATED_MODEL_QQ138
QQ139 0 NetQ133_2 NetQ133_3  GENERATED_MODEL_QQ139
QQ141 NetQ119_3 Basen2 0  GENERATED_MODEL_QQ141
QQ143 NetQ143_1 basep2 NetQ124_1  GENERATED_MODEL_QQ143
QQ146 NetQ146_1 basep2 NetQ125_1  GENERATED_MODEL_QQ146
QQ147 NetC4_1 NetQ147_3 NetQ121_2  GENERATED_MODEL_QQ147
QQ148 NetQ148_2 NetQ148_3 NetQ130_2  GENERATED_MODEL_QQ148
QQ149 NetQ148_2 NetQ148_3 NetQ130_2  GENERATED_MODEL_QQ149
QQ150 NetP1_1 NetP3_2 NetC1_1  GENERATED_MODEL_QQ150
QQ151 NetP3_1 NetP3_1 NetQ151_1  GENERATED_MODEL_QQ151
QQ152 NetP3_1 NetP3_1 NetQ151_1  GENERATED_MODEL_QQ152
QQ153 NetQ153_2 NetQ153_3 NetQ133_2  GENERATED_MODEL_QQ153
QQ154 NetQ153_2 NetQ153_3 NetQ133_2  GENERATED_MODEL_QQ154
QQ155 NetC5_1 NetQ147_3 NetQ127_2  GENERATED_MODEL_QQ155
QQ156 NetQ156_2 NetQ147_3 NetQ128_2  GENERATED_MODEL_QQ156
QQ157 NetQ156_2 NetQ147_3 NetQ128_2  GENERATED_MODEL_QQ157
QQ158 NetP2_2 NetP2_2 NetQ158_1  GENERATED_MODEL_QQ158
QQ159 NetP2_2 NetP2_2 NetQ158_1  GENERATED_MODEL_QQ159
QQ160 NetP1_1 NetQ160_3 NetC2_1  GENERATED_MODEL_QQ160
QQ161 0 NetQ153_2 NetQ153_3  GENERATED_MODEL_QQ161
QQ162 0 NetQ146_1 basep2  GENERATED_MODEL_QQ162
QQ164 0 NetQ156_2 NetQ147_3  GENERATED_MODEL_QQ164
QQ165 0 NetQ148_2 NetQ148_3  GENERATED_MODEL_QQ165
QQ166 NetP1_1 NetQ148_2 NetQ166_1  GENERATED_MODEL_QQ166
QQ169 NetQ169_1 Basep1 NetP1_1  GENERATED_MODEL_QQ169
QQ170 NetQ143_1 NetQ143_1 NetQ170_3  GENERATED_MODEL_QQ170
QQ171 NetQ146_1 NetQ143_1 NetQ171_3  GENERATED_MODEL_QQ171
QQ172 NetP1_1 NetQ153_2 NetQ172_1  GENERATED_MODEL_QQ172
QQ176 NetQ148_2 NetQ166_1 NetC2_2  GENERATED_MODEL_QQ176
QQ177 NetQ148_2 NetQ166_1 NetC2_2  GENERATED_MODEL_QQ177
QQ179 NetC4_1 NetQ156_2 NetQ179_1  GENERATED_MODEL_QQ179
QQ180 NetQ151_1 NetQ180_3 NetQ180_1  GENERATED_MODEL_QQ180
QQ182 NetQ151_1 NetQ180_3 NetQ180_1  GENERATED_MODEL_QQ182
QQ183 NetQ153_2 NetQ172_1 NetC1_2  GENERATED_MODEL_QQ183
QQ186 NetQ153_2 NetQ172_1 NetC1_2  GENERATED_MODEL_QQ186
QQ189 NetC5_1 NetQ156_2 NetQ189_1  GENERATED_MODEL_QQ189
QQ190 NetQ156_2 NetQ156_2 NetQ190_1  GENERATED_MODEL_QQ190
QQ192 NetQ156_2 NetQ156_2 NetQ190_1  GENERATED_MODEL_QQ192
QQ193 NetQ158_1 NetQ193_3 NetQ193_1  GENERATED_MODEL_QQ193
QQ194 NetQ158_1 NetQ193_3 NetQ193_1  GENERATED_MODEL_QQ194
QQ195 NetQ120_2 NetQ120_2 NetQ195_1  GENERATED_MODEL_QQ195
QQ197 NetQ120_2 NetQ120_2 NetQ195_1  GENERATED_MODEL_QQ197
QQ199 NetQ170_3 NetQ170_3 NetQ199_3  GENERATED_MODEL_QQ199
QQ200 NetQ171_3 NetQ170_3 NetQ200_3  GENERATED_MODEL_QQ200
QQ203 NetP1_1 NetQ126_1 Basen2  GENERATED_MODEL_QQ203
QQ212 NetQ212_1 Basep1 NetP1_1  GENERATED_MODEL_QQ212
QQ213 NetP1_1 NetQ158_1 NetQ193_3  GENERATED_MODEL_QQ213
QQ214 NetQ180_1 NetQ214_3 0  GENERATED_MODEL_QQ214
QQ215 NetQ193_1 NetQ215_3 0  GENERATED_MODEL_QQ215
QQ217 NetP1_1 NetQ151_1 NetQ180_3  GENERATED_MODEL_QQ217
QQ219 NetQ195_1 NetQ219_3 NetQ219_1  GENERATED_MODEL_QQ219
QQ220 NetQ195_1 NetQ219_3 NetQ219_1  GENERATED_MODEL_QQ220
QQ221 NetC2_1 NetQ219_3 NetQ221_1  GENERATED_MODEL_QQ221
QQ223 NetC1_1 NetQ219_3 NetQ221_1  GENERATED_MODEL_QQ223
QQ224 NetQ179_1 NetQ224_3 NetQ224_1  GENERATED_MODEL_QQ224
QQ225 NetC2_2 NetC2_2 NetQ225_1  GENERATED_MODEL_QQ225
QQ226 NetC2_2 NetC2_2 NetQ225_1  GENERATED_MODEL_QQ226
QQ227 NetQ126_1 Basen2 0  GENERATED_MODEL_QQ227
QQ228 NetC1_2 NetC1_2 NetQ228_1  GENERATED_MODEL_QQ228
QQ229 NetC1_2 NetC1_2 NetQ228_1  GENERATED_MODEL_QQ229
QQ231 NetQ189_1 NetQ231_3 NetQ224_1  GENERATED_MODEL_QQ231
QQ233 NetQ190_1 NetQ190_1 NetQ233_1  GENERATED_MODEL_QQ233
QQ234 NetQ190_1 NetQ190_1 NetQ233_1  GENERATED_MODEL_QQ234
QQ238 NetQ212_1 NetQ212_1 0  GENERATED_MODEL_QQ238
QQ240 NetQ225_1 NetQ212_1 0  GENERATED_MODEL_QQ240
QQ242 NetQ219_1 NetQ242_3 0  GENERATED_MODEL_QQ242
QQ243 NetQ221_1 NetQ242_3 0  GENERATED_MODEL_QQ243
QQ245 NetQ228_1 NetQ212_1 0  GENERATED_MODEL_QQ245
QQ246 NetQ169_1 NetQ169_1 0  GENERATED_MODEL_QQ246
QQ247 NetQ224_1 NetQ169_1 0  GENERATED_MODEL_QQ247
QQ248 NetQ233_1 NetQ169_1 0  GENERATED_MODEL_QQ248
QQ251 0 0 NetQ199_3  GENERATED_MODEL_QQ251
QQ252 0 0 NetQ252_3  GENERATED_MODEL_QQ252
QQ254 0 0 NetQ252_3  GENERATED_MODEL_QQ254
QQ255 0 0 NetQ252_3  GENERATED_MODEL_QQ255
QQ257 0 0 NetQ252_3  GENERATED_MODEL_QQ257
QQ258 0 0 NetQ252_3  GENERATED_MODEL_QQ258
QQ261 NetP1_1 NetQ195_1 NetQ219_3  GENERATED_MODEL_QQ261
QQ262 NetP1_1 NetQ219_1 NetQ242_3  GENERATED_MODEL_QQ262
QQ264 NetP1_1 NetQ193_1 NetQ215_3  GENERATED_MODEL_QQ264
QQ265 NetP1_1 NetQ180_1 NetQ214_3  GENERATED_MODEL_QQ265
QQ274 NetQ274_2 NetQ274_3 NetP1_1  GENERATED_MODEL_QQ274
QQ275 NetQ274_3 NetQ274_3 NetP1_1  GENERATED_MODEL_QQ275
QQ279 NetQ279_1 Basep1 NetP1_1  GENERATED_MODEL_QQ279
QQ283 NetQ283_2 NetC4_1 NetQ274_3  GENERATED_MODEL_QQ283
QQ288 NetQ283_2 NetC5_1 NetQ274_2  GENERATED_MODEL_QQ288
QQ289 NetQ279_1 NetQ279_1 0  GENERATED_MODEL_QQ289
QQ292 NetQ283_2 NetQ279_1 0  GENERATED_MODEL_QQ292
RR1 NetQ127_2 NetQ121_3 600k
RR2 NetQ121_2 NetQ121_3 600k
RR3 NetC5_1 NetQ147_3 600k
RR4 NetC4_1 NetQ147_3 600k
RR5 NetQ156_2 NetC5_1 600k
RR6 NetQ156_2 NetC4_1 600k
RR7 NetQ231_3 NetQ189_1 600k
RR8 NetQ224_3 NetQ179_1 600k
RR9 NetQ231_3 NetC5_1 100k
RR10 NetQ252_3 NetQ200_3 20
RR11 NetQ274_2 NetQ7_2 5k
RR12 NetQ4_2 NetQ17_2 5k
RR13 NetQ224_3 NetC4_1 100k
RR14 NetQ231_3 NetC1_2 1K
RR15 NetQ160_3 NetR15_2 9Meg
RR16 NetR15_2 NetQ15_2 1Meg
RR17 NetC2_2 NetQ224_3 1K
RR18 NetP2_1 NetQ160_3 10K
RR23 NetC3_2 NetQ4_3 100
RR24 NetQ4_2 NetQ4_3 33k
RR25 NetQ15_2 0 11.1k
VV6 NetP1_1 0 6 AC 1 0
VV10 NetP3_2 NetP3_1 DC 0 SIN(0 2m 100k 0 0 0) AC 0 0
VV11 NetP2_1 NetP2_2 DC 0 SIN(0 1m 100k 0 0 0) AC 0 0

*Selected Circuit Analyses:
.AC DEC 10 1K 1G
.TRAN 5n 500u
.OP ALL

.OPTION POST=2
.OPTIONS RELTOL=1e-3
.OPTIONS ABSTOL=1e-6
.OPTIONS VNTOL=1e-6

*Models and Subcircuits:
.SYNTAX LTSPICE
.MODEL GENERATED_MODEL_QQ1 PNP( AF=0 BF=310 BR=1 CJC=3pf CJE=20pf CJS=0 EG=1.11
+ FC=0.5 IKF=12.5e-3 IKR=0 IRB=0 IS=6.58e-18 ISC=0 ISE=0 ISS=0 ITF=0 MJC=0.33
+ MJE=0.33 MJS=0 NC=2 NE=1.5 NF=1 NR=1 NS=1 PTF=0 RB=0 RBM=0 RC=0 RE=0 TF=1.59e-9
+ TR=0 TRB1=0 TRB2=0 TRC1=0 TRC2=0 TRE1=0 TRE2=0 TRM1=0 TRM2=0 VAF=100 VAR=0
+ VJC=0.75 VJE=0.75 VJS=0.75 VTF=0 XCJC=1 XTB=0 XTF=0 XTI=3 )
.ENDSYNTAX

.SYNTAX LTSPICE
.MODEL GENERATED_MODEL_QQ2 PNP( AF=0 BF=310 BR=1 CJC=3pf CJE=20pf CJS=0 EG=1.11
+ FC=0.5 IKF=12.5e-3 IKR=0 IRB=0 IS=6.58e-18 ISC=0 ISE=0 ISS=0 ITF=0 MJC=0.33
+ MJE=0.33 MJS=0 NC=2 NE=1.5 NF=1 NR=1 NS=1 PTF=0 RB=0 RBM=0 RC=0 RE=0 TF=1.59e-9
+ TR=0 TRB1=0 TRB2=0 TRC1=0 TRC2=0 TRE1=0 TRE2=0 TRM1=0 TRM2=0 VAF=100 VAR=0
+ VJC=0.75 VJE=0.75 VJS=0.75 VTF=0 XCJC=1 XTB=0 XTF=0 XTI=3 )
.ENDSYNTAX

.SYNTAX LTSPICE
.MODEL GENERATED_MODEL_QQ3 PNP( AF=0 BF=310 BR=1 CJC=3pf CJE=20pf CJS=0 EG=1.11
+ FC=0.5 IKF=12.5e-3 IKR=0 IRB=0 IS=6.58e-18 ISC=0 ISE=0 ISS=0 ITF=0 MJC=0.33
+ MJE=0.33 MJS=0 NC=2 NE=1.5 NF=1 NR=1 NS=1 PTF=0 RB=0 RBM=0 RC=0 RE=0 TF=1.59e-9
+ TR=0 TRB1=0 TRB2=0 TRC1=0 TRC2=0 TRE1=0 TRE2=0 TRM1=0 TRM2=0 VAF=100 VAR=0
+ VJC=0.75 VJE=0.75 VJS=0.75 VTF=0 XCJC=1 XTB=0 XTF=0 XTI=3 )
.ENDSYNTAX

.SYNTAX LTSPICE
.MODEL GENERATED_MODEL_QQ4 PNP( AF=0 BF=310 BR=1 CJC=3pf CJE=20pf CJS=0 EG=1.11
+ FC=0.5 IKF=12.5e-3 IKR=0 IRB=0 IS=6.58e-18 ISC=0 ISE=0 ISS=0 ITF=0 MJC=0.33
+ MJE=0.33 MJS=0 NC=2 NE=1.5 NF=1 NR=1 NS=1 PTF=0 RB=0 RBM=0 RC=0 RE=0 TF=1.59e-9
+ TR=0 TRB1=0 TRB2=0 TRC1=0 TRC2=0 TRE1=0 TRE2=0 TRM1=0 TRM2=0 VAF=100 VAR=0
+ VJC=0.75 VJE=0.75 VJS=0.75 VTF=0 XCJC=1 XTB=0 XTF=0 XTI=3 )
.ENDSYNTAX

.SYNTAX LTSPICE
.MODEL GENERATED_MODEL_QQ5 PNP( AF=0 BF=310 BR=1 CJC=3pf CJE=20pf CJS=0 EG=1.11
+ FC=0.5 IKF=12.5e-3 IKR=0 IRB=0 IS=6.58e-18 ISC=0 ISE=0 ISS=0 ITF=0 MJC=0.33
+ MJE=0.33 MJS=0 NC=2 NE=1.5 NF=1 NR=1 NS=1 PTF=0 RB=0 RBM=0 RC=0 RE=0 TF=1.59e-9
+ TR=0 TRB1=0 TRB2=0 TRC1=0 TRC2=0 TRE1=0 TRE2=0 TRM1=0 TRM2=0 VAF=100 VAR=0
+ VJC=0.75 VJE=0.75 VJS=0.75 VTF=0 XCJC=1 XTB=0 XTF=0 XTI=3 )
.ENDSYNTAX

.SYNTAX LTSPICE
.MODEL GENERATED_MODEL_QQ6 PNP( AF=0 BF=430 BR=3 CJC=2.5pf CJE=6pf CJS=0 EG=1.11
+ FC=0.5 IKF=25e-3 IKR=0 IRB=0 IS=1.43e-16 ISC=0 ISE=0 ISS=0 ITF=0 KF=0 MJC=0.33
+ MJE=0.33 MJS=0 NC=2 NE=1.5 NF=1 NR=1 NS=1 PTF=0 RB=0 RBM=0 RC=0 RE=0 TF=0 TR=0
+ TRB1=0 TRB2=0 TRC1=0 TRC2=0 TRE1=0 TRE2=0 TRM1=0 TRM2=0 VAF=50 VAR=0 VJC=0.75
+ VJE=0.75 VJS=0.75 VTF=0 XCJC=1 XTB=0 XTF=0 XTI=3 )
.ENDSYNTAX

.SYNTAX LTSPICE
.MODEL GENERATED_MODEL_QQ7 PNP( AF=0 BF=310 BR=1 CJC=3pf CJE=20pf CJS=0 EG=1.11
+ FC=0.5 IKF=12.5e-3 IKR=0 IRB=0 IS=6.58e-18 ISC=0 ISE=0 ISS=0 ITF=0 MJC=0.33
+ MJE=0.33 MJS=0 NC=2 NE=1.5 NF=1 NR=1 NS=1 PTF=0 RB=0 RBM=0 RC=0 RE=0 TF=1.59e-9
+ TR=0 TRB1=0 TRB2=0 TRC1=0 TRC2=0 TRE1=0 TRE2=0 TRM1=0 TRM2=0 VAF=100 VAR=0
+ VJC=0.75 VJE=0.75 VJS=0.75 VTF=0 XCJC=1 XTB=0 XTF=0 XTI=3 )
.ENDSYNTAX

.SYNTAX LTSPICE
.MODEL GENERATED_MODEL_QQ8 NPN( AF=0 BF=320 BR=1 CJC=3.7pf CJE=13pf CJS=0 EG=1.11
+ FC=0.5 IKF=12.5e-3 IKR=0 IRB=0 IS=6.58e-18 ISC=0 ISE=0 ISS=0 ITF=0 KF=0 MJC=0.33
+ MJE=0.33 MJS=0 NC=2 NE=1.5 NF=1 NR=1 NS=1 PTF=0 RB=0 RBM=0 RC=0 RE=0 TF=1.44e-9
+ TNOM=27 TR=0 TRB1=0 TRB2=0 TRC1=0 TRC2=0 TRE1=0 TRE2=0 TRM1=0 TRM2=0 VAF=150
+ VAR=0 VJC=0.75 VJE=0.75 VJS=0.75 VTF=0 XCJC=1 XTB=0 XTF=0 XTI=3 )
.ENDSYNTAX

.SYNTAX LTSPICE
.MODEL GENERATED_MODEL_QQ9 NPN( AF=0 BF=320 BR=1 CJC=3.7pf CJE=13pf CJS=0 EG=1.11
+ FC=0.5 IKF=12.5e-3 IKR=0 IRB=0 IS=6.58e-18 ISC=0 ISE=0 ISS=0 ITF=0 KF=0 MJC=0.33
+ MJE=0.33 MJS=0 NC=2 NE=1.5 NF=1 NR=1 NS=1 PTF=0 RB=0 RBM=0 RC=0 RE=0 TF=1.44e-9
+ TNOM=27 TR=0 TRB1=0 TRB2=0 TRC1=0 TRC2=0 TRE1=0 TRE2=0 TRM1=0 TRM2=0 VAF=150
+ VAR=0 VJC=0.75 VJE=0.75 VJS=0.75 VTF=0 XCJC=1 XTB=0 XTF=0 XTI=3 )
.ENDSYNTAX

.SYNTAX LTSPICE
.MODEL GENERATED_MODEL_QQ10 PNP( AF=0 BF=310 BR=1 CJC=3pf CJE=20pf CJS=0 EG=1.11
+ FC=0.5 IKF=12.5e-3 IKR=0 IRB=0 IS=6.58e-18 ISC=0 ISE=0 ISS=0 ITF=0 MJC=0.33
+ MJE=0.33 MJS=0 NC=2 NE=1.5 NF=1 NR=1 NS=1 PTF=0 RB=0 RBM=0 RC=0 RE=0 TF=1.59e-9
+ TR=0 TRB1=0 TRB2=0 TRC1=0 TRC2=0 TRE1=0 TRE2=0 TRM1=0 TRM2=0 VAF=100 VAR=0
+ VJC=0.75 VJE=0.75 VJS=0.75 VTF=0 XCJC=1 XTB=0 XTF=0 XTI=3 )
.ENDSYNTAX

.SYNTAX LTSPICE
.MODEL GENERATED_MODEL_QQ11 PNP( AF=0 BF=310 BR=1 CJC=3pf CJE=20pf CJS=0 EG=1.11
+ FC=0.5 IKF=12.5e-3 IKR=0 IRB=0 IS=6.58e-18 ISC=0 ISE=0 ISS=0 ITF=0 MJC=0.33
+ MJE=0.33 MJS=0 NC=2 NE=1.5 NF=1 NR=1 NS=1 PTF=0 RB=0 RBM=0 RC=0 RE=0 TF=1.59e-9
+ TR=0 TRB1=0 TRB2=0 TRC1=0 TRC2=0 TRE1=0 TRE2=0 TRM1=0 TRM2=0 VAF=100 VAR=0
+ VJC=0.75 VJE=0.75 VJS=0.75 VTF=0 XCJC=1 XTB=0 XTF=0 XTI=3 )
.ENDSYNTAX

.SYNTAX LTSPICE
.MODEL GENERATED_MODEL_QQ12 NPN( AF=0 BF=444 BR=3 CJC=2.5pf CJE=4pf CJS=0 EG=1.11
+ FC=0.5 IKF=25e-3 IKR=0 IRB=0 IS=1.43e-16 ISC=0 ISE=0 ISS=0 ITF=0 KF=0 MJC=0.33
+ MJE=0.33 MJS=0 NC=2 NE=1.5 NF=1 NR=1 NS=1 PTF=0 RB=0 RBM=0 RC=0 RE=0 TF=6.37e-10
+ TR=0 TRB1=0 TRB2=0 TRC1=0 TRC2=0 TRE1=0 TRE2=0 TRM1=0 TRM2=0 VAF=100 VAR=0
+ VJC=0.75 VJE=0.75 VJS=0.75 VTF=0 XCJC=1 XTB=0 XTF=0 XTI=3 )
.ENDSYNTAX

.SYNTAX LTSPICE
.MODEL GENERATED_MODEL_QQ13 PNP( AF=0 BF=430 BR=3 CJC=2.5pf CJE=6pf CJS=0 EG=1.11
+ FC=0.5 IKF=25e-3 IKR=0 IRB=0 IS=1.43e-16 ISC=0 ISE=0 ISS=0 ITF=0 KF=0 MJC=0.33
+ MJE=0.33 MJS=0 NC=2 NE=1.5 NF=1 NR=1 NS=1 PTF=0 RB=0 RBM=0 RC=0 RE=0 TF=0 TR=0
+ TRB1=0 TRB2=0 TRC1=0 TRC2=0 TRE1=0 TRE2=0 TRM1=0 TRM2=0 VAF=50 VAR=0 VJC=0.75
+ VJE=0.75 VJS=0.75 VTF=0 XCJC=1 XTB=0 XTF=0 XTI=3 )
.ENDSYNTAX

.SYNTAX LTSPICE
.MODEL GENERATED_MODEL_QQ14 PNP( AF=0 BF=310 BR=1 CJC=3pf CJE=20pf CJS=0 EG=1.11
+ FC=0.5 IKF=12.5e-3 IKR=0 IRB=0 IS=6.58e-18 ISC=0 ISE=0 ISS=0 ITF=0 MJC=0.33
+ MJE=0.33 MJS=0 NC=2 NE=1.5 NF=1 NR=1 NS=1 PTF=0 RB=0 RBM=0 RC=0 RE=0 TF=1.59e-9
+ TR=0 TRB1=0 TRB2=0 TRC1=0 TRC2=0 TRE1=0 TRE2=0 TRM1=0 TRM2=0 VAF=100 VAR=0
+ VJC=0.75 VJE=0.75 VJS=0.75 VTF=0 XCJC=1 XTB=0 XTF=0 XTI=3 )
.ENDSYNTAX

.SYNTAX LTSPICE
.MODEL GENERATED_MODEL_QQ15 PNP( AF=0 BF=310 BR=1 CJC=3pf CJE=20pf CJS=0 EG=1.11
+ FC=0.5 IKF=12.5e-3 IKR=0 IRB=0 IS=6.58e-18 ISC=0 ISE=0 ISS=0 ITF=0 MJC=0.33
+ MJE=0.33 MJS=0 NC=2 NE=1.5 NF=1 NR=1 NS=1 PTF=0 RB=0 RBM=0 RC=0 RE=0 TF=1.59e-9
+ TR=0 TRB1=0 TRB2=0 TRC1=0 TRC2=0 TRE1=0 TRE2=0 TRM1=0 TRM2=0 VAF=100 VAR=0
+ VJC=0.75 VJE=0.75 VJS=0.75 VTF=0 XCJC=1 XTB=0 XTF=0 XTI=3 )
.ENDSYNTAX

.SYNTAX LTSPICE
.MODEL GENERATED_MODEL_QQ16 PNP( AF=0 BF=310 BR=1 CJC=3pf CJE=20pf CJS=0 EG=1.11
+ FC=0.5 IKF=12.5e-3 IKR=0 IRB=0 IS=6.58e-18 ISC=0 ISE=0 ISS=0 ITF=0 MJC=0.33
+ MJE=0.33 MJS=0 NC=2 NE=1.5 NF=1 NR=1 NS=1 PTF=0 RB=0 RBM=0 RC=0 RE=0 TF=1.59e-9
+ TR=0 TRB1=0 TRB2=0 TRC1=0 TRC2=0 TRE1=0 TRE2=0 TRM1=0 TRM2=0 VAF=100 VAR=0
+ VJC=0.75 VJE=0.75 VJS=0.75 VTF=0 XCJC=1 XTB=0 XTF=0 XTI=3 )
.ENDSYNTAX

.SYNTAX LTSPICE
.MODEL GENERATED_MODEL_QQ17 PNP( AF=0 BF=310 BR=1 CJC=3pf CJE=20pf CJS=0 EG=1.11
+ FC=0.5 IKF=12.5e-3 IKR=0 IRB=0 IS=6.58e-18 ISC=0 ISE=0 ISS=0 ITF=0 MJC=0.33
+ MJE=0.33 MJS=0 NC=2 NE=1.5 NF=1 NR=1 NS=1 PTF=0 RB=0 RBM=0 RC=0 RE=0 TF=1.59e-9
+ TR=0 TRB1=0 TRB2=0 TRC1=0 TRC2=0 TRE1=0 TRE2=0 TRM1=0 TRM2=0 VAF=100 VAR=0
+ VJC=0.75 VJE=0.75 VJS=0.75 VTF=0 XCJC=1 XTB=0 XTF=0 XTI=3 )
.ENDSYNTAX

.SYNTAX LTSPICE
.MODEL GENERATED_MODEL_QQ18 PNP( AF=0 BF=310 BR=1 CJC=3pf CJE=20pf CJS=0 EG=1.11
+ FC=0.5 IKF=12.5e-3 IKR=0 IRB=0 IS=6.58e-18 ISC=0 ISE=0 ISS=0 ITF=0 MJC=0.33
+ MJE=0.33 MJS=0 NC=2 NE=1.5 NF=1 NR=1 NS=1 PTF=0 RB=0 RBM=0 RC=0 RE=0 TF=1.59e-9
+ TR=0 TRB1=0 TRB2=0 TRC1=0 TRC2=0 TRE1=0 TRE2=0 TRM1=0 TRM2=0 VAF=100 VAR=0
+ VJC=0.75 VJE=0.75 VJS=0.75 VTF=0 XCJC=1 XTB=0 XTF=0 XTI=3 )
.ENDSYNTAX

.SYNTAX LTSPICE
.MODEL GENERATED_MODEL_QQ19 PNP( AF=0 BF=310 BR=1 CJC=3pf CJE=20pf CJS=0 EG=1.11
+ FC=0.5 IKF=12.5e-3 IKR=0 IRB=0 IS=6.58e-18 ISC=0 ISE=0 ISS=0 ITF=0 MJC=0.33
+ MJE=0.33 MJS=0 NC=2 NE=1.5 NF=1 NR=1 NS=1 PTF=0 RB=0 RBM=0 RC=0 RE=0 TF=1.59e-9
+ TR=0 TRB1=0 TRB2=0 TRC1=0 TRC2=0 TRE1=0 TRE2=0 TRM1=0 TRM2=0 VAF=100 VAR=0
+ VJC=0.75 VJE=0.75 VJS=0.75 VTF=0 XCJC=1 XTB=0 XTF=0 XTI=3 )
.ENDSYNTAX

.SYNTAX LTSPICE
.MODEL GENERATED_MODEL_QQ20 PNP( AF=0 BF=310 BR=1 CJC=3pf CJE=20pf CJS=0 EG=1.11
+ FC=0.5 IKF=12.5e-3 IKR=0 IRB=0 IS=6.58e-18 ISC=0 ISE=0 ISS=0 ITF=0 MJC=0.33
+ MJE=0.33 MJS=0 NC=2 NE=1.5 NF=1 NR=1 NS=1 PTF=0 RB=0 RBM=0 RC=0 RE=0 TF=1.59e-9
+ TR=0 TRB1=0 TRB2=0 TRC1=0 TRC2=0 TRE1=0 TRE2=0 TRM1=0 TRM2=0 VAF=100 VAR=0
+ VJC=0.75 VJE=0.75 VJS=0.75 VTF=0 XCJC=1 XTB=0 XTF=0 XTI=3 )
.ENDSYNTAX

.SYNTAX LTSPICE
.MODEL GENERATED_MODEL_QQ21 PNP( AF=0 BF=310 BR=1 CJC=3pf CJE=20pf CJS=0 EG=1.11
+ FC=0.5 IKF=12.5e-3 IKR=0 IRB=0 IS=6.58e-18 ISC=0 ISE=0 ISS=0 ITF=0 MJC=0.33
+ MJE=0.33 MJS=0 NC=2 NE=1.5 NF=1 NR=1 NS=1 PTF=0 RB=0 RBM=0 RC=0 RE=0 TF=1.59e-9
+ TR=0 TRB1=0 TRB2=0 TRC1=0 TRC2=0 TRE1=0 TRE2=0 TRM1=0 TRM2=0 VAF=100 VAR=0
+ VJC=0.75 VJE=0.75 VJS=0.75 VTF=0 XCJC=1 XTB=0 XTF=0 XTI=3 )
.ENDSYNTAX

.SYNTAX LTSPICE
.MODEL GENERATED_MODEL_QQ22 PNP( AF=0 BF=430 BR=3 CJC=2.5pf CJE=6pf CJS=0 EG=1.11
+ FC=0.5 IKF=25e-3 IKR=0 IRB=0 IS=1.43e-16 ISC=0 ISE=0 ISS=0 ITF=0 KF=0 MJC=0.33
+ MJE=0.33 MJS=0 NC=2 NE=1.5 NF=1 NR=1 NS=1 PTF=0 RB=0 RBM=0 RC=0 RE=0 TF=0 TR=0
+ TRB1=0 TRB2=0 TRC1=0 TRC2=0 TRE1=0 TRE2=0 TRM1=0 TRM2=0 VAF=50 VAR=0 VJC=0.75
+ VJE=0.75 VJS=0.75 VTF=0 XCJC=1 XTB=0 XTF=0 XTI=3 )
.ENDSYNTAX

.SYNTAX LTSPICE
.MODEL GENERATED_MODEL_QQ23 PNP( AF=0 BF=310 BR=1 CJC=3pf CJE=20pf CJS=0 EG=1.11
+ FC=0.5 IKF=12.5e-3 IKR=0 IRB=0 IS=6.58e-18 ISC=0 ISE=0 ISS=0 ITF=0 MJC=0.33
+ MJE=0.33 MJS=0 NC=2 NE=1.5 NF=1 NR=1 NS=1 PTF=0 RB=0 RBM=0 RC=0 RE=0 TF=1.59e-9
+ TR=0 TRB1=0 TRB2=0 TRC1=0 TRC2=0 TRE1=0 TRE2=0 TRM1=0 TRM2=0 VAF=100 VAR=0
+ VJC=0.75 VJE=0.75 VJS=0.75 VTF=0 XCJC=1 XTB=0 XTF=0 XTI=3 )
.ENDSYNTAX

.SYNTAX LTSPICE
.MODEL GENERATED_MODEL_QQ24 NPN( AF=0 BF=444 BR=3 CJC=2.5pf CJE=4pf CJS=0 EG=1.11
+ FC=0.5 IKF=25e-3 IKR=0 IRB=0 IS=1.43e-16 ISC=0 ISE=0 ISS=0 ITF=0 KF=0 MJC=0.33
+ MJE=0.33 MJS=0 NC=2 NE=1.5 NF=1 NR=1 NS=1 PTF=0 RB=0 RBM=0 RC=0 RE=0 TF=6.37e-10
+ TR=0 TRB1=0 TRB2=0 TRC1=0 TRC2=0 TRE1=0 TRE2=0 TRM1=0 TRM2=0 VAF=100 VAR=0
+ VJC=0.75 VJE=0.75 VJS=0.75 VTF=0 XCJC=1 XTB=0 XTF=0 XTI=3 )
.ENDSYNTAX

.SYNTAX LTSPICE
.MODEL GENERATED_MODEL_QQ26 NPN( AF=0 BF=320 BR=1 CJC=3.7pf CJE=13pf CJS=0
+ EG=1.11 FC=0.5 IKF=12.5e-3 IKR=0 IRB=0 IS=6.58e-18 ISC=0 ISE=0 ISS=0 ITF=0 KF=0
+ MJC=0.33 MJE=0.33 MJS=0 NC=2 NE=1.5 NF=1 NR=1 NS=1 PTF=0 RB=0 RBM=0 RC=0 RE=0
+ TF=1.44e-9 TNOM=27 TR=0 TRB1=0 TRB2=0 TRC1=0 TRC2=0 TRE1=0 TRE2=0 TRM1=0 TRM2=0
+ VAF=150 VAR=0 VJC=0.75 VJE=0.75 VJS=0.75 VTF=0 XCJC=1 XTB=0 XTF=0 XTI=3 )
.ENDSYNTAX

.SYNTAX LTSPICE
.MODEL GENERATED_MODEL_QQ27 NPN( AF=0 BF=320 BR=1 CJC=3.7pf CJE=13pf CJS=0
+ EG=1.11 FC=0.5 IKF=12.5e-3 IKR=0 IRB=0 IS=6.58e-18 ISC=0 ISE=0 ISS=0 ITF=0 KF=0
+ MJC=0.33 MJE=0.33 MJS=0 NC=2 NE=1.5 NF=1 NR=1 NS=1 PTF=0 RB=0 RBM=0 RC=0 RE=0
+ TF=1.44e-9 TNOM=27 TR=0 TRB1=0 TRB2=0 TRC1=0 TRC2=0 TRE1=0 TRE2=0 TRM1=0 TRM2=0
+ VAF=150 VAR=0 VJC=0.75 VJE=0.75 VJS=0.75 VTF=0 XCJC=1 XTB=0 XTF=0 XTI=3 )
.ENDSYNTAX

.SYNTAX LTSPICE
.MODEL GENERATED_MODEL_QQ28 NPN( AF=0 BF=444 BR=3 CJC=2.5pf CJE=4pf CJS=0 EG=1.11
+ FC=0.5 IKF=25e-3 IKR=0 IRB=0 IS=1.43e-16 ISC=0 ISE=0 ISS=0 ITF=0 KF=0 MJC=0.33
+ MJE=0.33 MJS=0 NC=2 NE=1.5 NF=1 NR=1 NS=1 PTF=0 RB=0 RBM=0 RC=0 RE=0 TF=6.37e-10
+ TR=0 TRB1=0 TRB2=0 TRC1=0 TRC2=0 TRE1=0 TRE2=0 TRM1=0 TRM2=0 VAF=100 VAR=0
+ VJC=0.75 VJE=0.75 VJS=0.75 VTF=0 XCJC=1 XTB=0 XTF=0 XTI=3 )
.ENDSYNTAX

.SYNTAX LTSPICE
.MODEL GENERATED_MODEL_QQ29 NPN( AF=0 BF=444 BR=3 CJC=2.5pf CJE=4pf CJS=0 EG=1.11
+ FC=0.5 IKF=25e-3 IKR=0 IRB=0 IS=1.43e-16 ISC=0 ISE=0 ISS=0 ITF=0 KF=0 MJC=0.33
+ MJE=0.33 MJS=0 NC=2 NE=1.5 NF=1 NR=1 NS=1 PTF=0 RB=0 RBM=0 RC=0 RE=0 TF=6.37e-10
+ TR=0 TRB1=0 TRB2=0 TRC1=0 TRC2=0 TRE1=0 TRE2=0 TRM1=0 TRM2=0 VAF=100 VAR=0
+ VJC=0.75 VJE=0.75 VJS=0.75 VTF=0 XCJC=1 XTB=0 XTF=0 XTI=3 )
.ENDSYNTAX

.SYNTAX LTSPICE
.MODEL GENERATED_MODEL_QQ30 NPN( AF=0 BF=320 BR=1 CJC=3.7pf CJE=13pf CJS=0
+ EG=1.11 FC=0.5 IKF=12.5e-3 IKR=0 IRB=0 IS=6.58e-18 ISC=0 ISE=0 ISS=0 ITF=0 KF=0
+ MJC=0.33 MJE=0.33 MJS=0 NC=2 NE=1.5 NF=1 NR=1 NS=1 PTF=0 RB=0 RBM=0 RC=0 RE=0
+ TF=1.44e-9 TNOM=27 TR=0 TRB1=0 TRB2=0 TRC1=0 TRC2=0 TRE1=0 TRE2=0 TRM1=0 TRM2=0
+ VAF=150 VAR=0 VJC=0.75 VJE=0.75 VJS=0.75 VTF=0 XCJC=1 XTB=0 XTF=0 XTI=3 )
.ENDSYNTAX

.SYNTAX LTSPICE
.MODEL GENERATED_MODEL_QQ31 NPN( AF=0 BF=320 BR=1 CJC=3.7pf CJE=13pf CJS=0
+ EG=1.11 FC=0.5 IKF=12.5e-3 IKR=0 IRB=0 IS=6.58e-18 ISC=0 ISE=0 ISS=0 ITF=0 KF=0
+ MJC=0.33 MJE=0.33 MJS=0 NC=2 NE=1.5 NF=1 NR=1 NS=1 PTF=0 RB=0 RBM=0 RC=0 RE=0
+ TF=1.44e-9 TNOM=27 TR=0 TRB1=0 TRB2=0 TRC1=0 TRC2=0 TRE1=0 TRE2=0 TRM1=0 TRM2=0
+ VAF=150 VAR=0 VJC=0.75 VJE=0.75 VJS=0.75 VTF=0 XCJC=1 XTB=0 XTF=0 XTI=3 )
.ENDSYNTAX

.SYNTAX LTSPICE
.MODEL GENERATED_MODEL_QQ32 NPN( AF=0 BF=320 BR=1 CJC=3.7pf CJE=13pf CJS=0
+ EG=1.11 FC=0.5 IKF=12.5e-3 IKR=0 IRB=0 IS=6.58e-18 ISC=0 ISE=0 ISS=0 ITF=0 KF=0
+ MJC=0.33 MJE=0.33 MJS=0 NC=2 NE=1.5 NF=1 NR=1 NS=1 PTF=0 RB=0 RBM=0 RC=0 RE=0
+ TF=1.44e-9 TNOM=27 TR=0 TRB1=0 TRB2=0 TRC1=0 TRC2=0 TRE1=0 TRE2=0 TRM1=0 TRM2=0
+ VAF=150 VAR=0 VJC=0.75 VJE=0.75 VJS=0.75 VTF=0 XCJC=1 XTB=0 XTF=0 XTI=3 )
.ENDSYNTAX

.SYNTAX LTSPICE
.MODEL GENERATED_MODEL_QQ33 NPN( AF=0 BF=320 BR=1 CJC=3.7pf CJE=13pf CJS=0
+ EG=1.11 FC=0.5 IKF=12.5e-3 IKR=0 IRB=0 IS=6.58e-18 ISC=0 ISE=0 ISS=0 ITF=0 KF=0
+ MJC=0.33 MJE=0.33 MJS=0 NC=2 NE=1.5 NF=1 NR=1 NS=1 PTF=0 RB=0 RBM=0 RC=0 RE=0
+ TF=1.44e-9 TNOM=27 TR=0 TRB1=0 TRB2=0 TRC1=0 TRC2=0 TRE1=0 TRE2=0 TRM1=0 TRM2=0
+ VAF=150 VAR=0 VJC=0.75 VJE=0.75 VJS=0.75 VTF=0 XCJC=1 XTB=0 XTF=0 XTI=3 )
.ENDSYNTAX

.SYNTAX LTSPICE
.MODEL GENERATED_MODEL_QQ34 PNP( AF=0 BF=310 BR=1 CJC=3pf CJE=20pf CJS=0 EG=1.11
+ FC=0.5 IKF=12.5e-3 IKR=0 IRB=0 IS=6.58e-18 ISC=0 ISE=0 ISS=0 ITF=0 MJC=0.33
+ MJE=0.33 MJS=0 NC=2 NE=1.5 NF=1 NR=1 NS=1 PTF=0 RB=0 RBM=0 RC=0 RE=0 TF=1.59e-9
+ TR=0 TRB1=0 TRB2=0 TRC1=0 TRC2=0 TRE1=0 TRE2=0 TRM1=0 TRM2=0 VAF=100 VAR=0
+ VJC=0.75 VJE=0.75 VJS=0.75 VTF=0 XCJC=1 XTB=0 XTF=0 XTI=3 )
.ENDSYNTAX

.SYNTAX LTSPICE
.MODEL GENERATED_MODEL_QQ35 PNP( AF=0 BF=310 BR=1 CJC=3pf CJE=20pf CJS=0 EG=1.11
+ FC=0.5 IKF=12.5e-3 IKR=0 IRB=0 IS=6.58e-18 ISC=0 ISE=0 ISS=0 ITF=0 MJC=0.33
+ MJE=0.33 MJS=0 NC=2 NE=1.5 NF=1 NR=1 NS=1 PTF=0 RB=0 RBM=0 RC=0 RE=0 TF=1.59e-9
+ TR=0 TRB1=0 TRB2=0 TRC1=0 TRC2=0 TRE1=0 TRE2=0 TRM1=0 TRM2=0 VAF=100 VAR=0
+ VJC=0.75 VJE=0.75 VJS=0.75 VTF=0 XCJC=1 XTB=0 XTF=0 XTI=3 )
.ENDSYNTAX

.SYNTAX LTSPICE
.MODEL GENERATED_MODEL_QQ36 PNP( AF=0 BF=310 BR=1 CJC=3pf CJE=20pf CJS=0 EG=1.11
+ FC=0.5 IKF=12.5e-3 IKR=0 IRB=0 IS=6.58e-18 ISC=0 ISE=0 ISS=0 ITF=0 MJC=0.33
+ MJE=0.33 MJS=0 NC=2 NE=1.5 NF=1 NR=1 NS=1 PTF=0 RB=0 RBM=0 RC=0 RE=0 TF=1.59e-9
+ TR=0 TRB1=0 TRB2=0 TRC1=0 TRC2=0 TRE1=0 TRE2=0 TRM1=0 TRM2=0 VAF=100 VAR=0
+ VJC=0.75 VJE=0.75 VJS=0.75 VTF=0 XCJC=1 XTB=0 XTF=0 XTI=3 )
.ENDSYNTAX

.SYNTAX LTSPICE
.MODEL GENERATED_MODEL_QQ37 NPN( AF=0 BF=444 BR=3 CJC=2.5pf CJE=4pf CJS=0 EG=1.11
+ FC=0.5 IKF=25e-3 IKR=0 IRB=0 IS=1.43e-16 ISC=0 ISE=0 ISS=0 ITF=0 KF=0 MJC=0.33
+ MJE=0.33 MJS=0 NC=2 NE=1.5 NF=1 NR=1 NS=1 PTF=0 RB=0 RBM=0 RC=0 RE=0 TF=6.37e-10
+ TR=0 TRB1=0 TRB2=0 TRC1=0 TRC2=0 TRE1=0 TRE2=0 TRM1=0 TRM2=0 VAF=100 VAR=0
+ VJC=0.75 VJE=0.75 VJS=0.75 VTF=0 XCJC=1 XTB=0 XTF=0 XTI=3 )
.ENDSYNTAX

.SYNTAX LTSPICE
.MODEL GENERATED_MODEL_QQ119 PNP( AF=0 BF=310 BR=1 CJC=3pf CJE=20pf CJS=0 EG=1.11
+ FC=0.5 IKF=12.5e-3 IKR=0 IRB=0 IS=6.58e-18 ISC=0 ISE=0 ISS=0 ITF=0 MJC=0.33
+ MJE=0.33 MJS=0 NC=2 NE=1.5 NF=1 NR=1 NS=1 PTF=0 RB=0 RBM=0 RC=0 RE=0 TF=1.59e-9
+ TR=0 TRB1=0 TRB2=0 TRC1=0 TRC2=0 TRE1=0 TRE2=0 TRM1=0 TRM2=0 VAF=100 VAR=0
+ VJC=0.75 VJE=0.75 VJS=0.75 VTF=0 XCJC=1 XTB=0 XTF=0 XTI=3 )
.ENDSYNTAX

.SYNTAX LTSPICE
.MODEL GENERATED_MODEL_QQ120 PNP( AF=0 BF=310 BR=1 CJC=3pf CJE=20pf CJS=0 EG=1.11
+ FC=0.5 IKF=12.5e-3 IKR=0 IRB=0 IS=6.58e-18 ISC=0 ISE=0 ISS=0 ITF=0 MJC=0.33
+ MJE=0.33 MJS=0 NC=2 NE=1.5 NF=1 NR=1 NS=1 PTF=0 RB=0 RBM=0 RC=0 RE=0 TF=1.59e-9
+ TR=0 TRB1=0 TRB2=0 TRC1=0 TRC2=0 TRE1=0 TRE2=0 TRM1=0 TRM2=0 VAF=100 VAR=0
+ VJC=0.75 VJE=0.75 VJS=0.75 VTF=0 XCJC=1 XTB=0 XTF=0 XTI=3 )
.ENDSYNTAX

.SYNTAX LTSPICE
.MODEL GENERATED_MODEL_QQ121 PNP( AF=0 BF=310 BR=1 CJC=3pf CJE=20pf CJS=0 EG=1.11
+ FC=0.5 IKF=12.5e-3 IKR=0 IRB=0 IS=6.58e-18 ISC=0 ISE=0 ISS=0 ITF=0 MJC=0.33
+ MJE=0.33 MJS=0 NC=2 NE=1.5 NF=1 NR=1 NS=1 PTF=0 RB=0 RBM=0 RC=0 RE=0 TF=1.59e-9
+ TR=0 TRB1=0 TRB2=0 TRC1=0 TRC2=0 TRE1=0 TRE2=0 TRM1=0 TRM2=0 VAF=100 VAR=0
+ VJC=0.75 VJE=0.75 VJS=0.75 VTF=0 XCJC=1 XTB=0 XTF=0 XTI=3 )
.ENDSYNTAX

.SYNTAX LTSPICE
.MODEL GENERATED_MODEL_QQ122 PNP( AF=0 BF=310 BR=1 CJC=3pf CJE=20pf CJS=0 EG=1.11
+ FC=0.5 IKF=12.5e-3 IKR=0 IRB=0 IS=6.58e-18 ISC=0 ISE=0 ISS=0 ITF=0 MJC=0.33
+ MJE=0.33 MJS=0 NC=2 NE=1.5 NF=1 NR=1 NS=1 PTF=0 RB=0 RBM=0 RC=0 RE=0 TF=1.59e-9
+ TR=0 TRB1=0 TRB2=0 TRC1=0 TRC2=0 TRE1=0 TRE2=0 TRM1=0 TRM2=0 VAF=100 VAR=0
+ VJC=0.75 VJE=0.75 VJS=0.75 VTF=0 XCJC=1 XTB=0 XTF=0 XTI=3 )
.ENDSYNTAX

.SYNTAX LTSPICE
.MODEL GENERATED_MODEL_QQ123 PNP( AF=0 BF=310 BR=1 CJC=3pf CJE=20pf CJS=0 EG=1.11
+ FC=0.5 IKF=12.5e-3 IKR=0 IRB=0 IS=6.58e-18 ISC=0 ISE=0 ISS=0 ITF=0 MJC=0.33
+ MJE=0.33 MJS=0 NC=2 NE=1.5 NF=1 NR=1 NS=1 PTF=0 RB=0 RBM=0 RC=0 RE=0 TF=1.59e-9
+ TR=0 TRB1=0 TRB2=0 TRC1=0 TRC2=0 TRE1=0 TRE2=0 TRM1=0 TRM2=0 VAF=100 VAR=0
+ VJC=0.75 VJE=0.75 VJS=0.75 VTF=0 XCJC=1 XTB=0 XTF=0 XTI=3 )
.ENDSYNTAX

.SYNTAX LTSPICE
.MODEL GENERATED_MODEL_QQ124 PNP( AF=0 BF=430 BR=3 CJC=2.5pf CJE=6pf CJS=0
+ EG=1.11 FC=0.5 IKF=25e-3 IKR=0 IRB=0 IS=1.43e-16 ISC=0 ISE=0 ISS=0 ITF=0 KF=0
+ MJC=0.33 MJE=0.33 MJS=0 NC=2 NE=1.5 NF=1 NR=1 NS=1 PTF=0 RB=0 RBM=0 RC=0 RE=0
+ TF=0 TR=0 TRB1=0 TRB2=0 TRC1=0 TRC2=0 TRE1=0 TRE2=0 TRM1=0 TRM2=0 VAF=50 VAR=0
+ VJC=0.75 VJE=0.75 VJS=0.75 VTF=0 XCJC=1 XTB=0 XTF=0 XTI=3 )
.ENDSYNTAX

.SYNTAX LTSPICE
.MODEL GENERATED_MODEL_QQ125 PNP( AF=0 BF=430 BR=3 CJC=2.5pf CJE=6pf CJS=0
+ EG=1.11 FC=0.5 IKF=25e-3 IKR=0 IRB=0 IS=1.43e-16 ISC=0 ISE=0 ISS=0 ITF=0 KF=0
+ MJC=0.33 MJE=0.33 MJS=0 NC=2 NE=1.5 NF=1 NR=1 NS=1 PTF=0 RB=0 RBM=0 RC=0 RE=0
+ TF=0 TR=0 TRB1=0 TRB2=0 TRC1=0 TRC2=0 TRE1=0 TRE2=0 TRM1=0 TRM2=0 VAF=50 VAR=0
+ VJC=0.75 VJE=0.75 VJS=0.75 VTF=0 XCJC=1 XTB=0 XTF=0 XTI=3 )
.ENDSYNTAX

.SYNTAX LTSPICE
.MODEL GENERATED_MODEL_QQ126 PNP( AF=0 BF=430 BR=3 CJC=2.5pf CJE=6pf CJS=0
+ EG=1.11 FC=0.5 IKF=25e-3 IKR=0 IRB=0 IS=1.43e-16 ISC=0 ISE=0 ISS=0 ITF=0 KF=0
+ MJC=0.33 MJE=0.33 MJS=0 NC=2 NE=1.5 NF=1 NR=1 NS=1 PTF=0 RB=0 RBM=0 RC=0 RE=0
+ TF=0 TR=0 TRB1=0 TRB2=0 TRC1=0 TRC2=0 TRE1=0 TRE2=0 TRM1=0 TRM2=0 VAF=50 VAR=0
+ VJC=0.75 VJE=0.75 VJS=0.75 VTF=0 XCJC=1 XTB=0 XTF=0 XTI=3 )
.ENDSYNTAX

.SYNTAX LTSPICE
.MODEL GENERATED_MODEL_QQ127 PNP( AF=0 BF=310 BR=1 CJC=3pf CJE=20pf CJS=0 EG=1.11
+ FC=0.5 IKF=12.5e-3 IKR=0 IRB=0 IS=6.58e-18 ISC=0 ISE=0 ISS=0 ITF=0 MJC=0.33
+ MJE=0.33 MJS=0 NC=2 NE=1.5 NF=1 NR=1 NS=1 PTF=0 RB=0 RBM=0 RC=0 RE=0 TF=1.59e-9
+ TR=0 TRB1=0 TRB2=0 TRC1=0 TRC2=0 TRE1=0 TRE2=0 TRM1=0 TRM2=0 VAF=100 VAR=0
+ VJC=0.75 VJE=0.75 VJS=0.75 VTF=0 XCJC=1 XTB=0 XTF=0 XTI=3 )
.ENDSYNTAX

.SYNTAX LTSPICE
.MODEL GENERATED_MODEL_QQ128 PNP( AF=0 BF=310 BR=1 CJC=3pf CJE=20pf CJS=0 EG=1.11
+ FC=0.5 IKF=12.5e-3 IKR=0 IRB=0 IS=6.58e-18 ISC=0 ISE=0 ISS=0 ITF=0 MJC=0.33
+ MJE=0.33 MJS=0 NC=2 NE=1.5 NF=1 NR=1 NS=1 PTF=0 RB=0 RBM=0 RC=0 RE=0 TF=1.59e-9
+ TR=0 TRB1=0 TRB2=0 TRC1=0 TRC2=0 TRE1=0 TRE2=0 TRM1=0 TRM2=0 VAF=100 VAR=0
+ VJC=0.75 VJE=0.75 VJS=0.75 VTF=0 XCJC=1 XTB=0 XTF=0 XTI=3 )
.ENDSYNTAX

.SYNTAX LTSPICE
.MODEL GENERATED_MODEL_QQ129 PNP( AF=0 BF=310 BR=1 CJC=3pf CJE=20pf CJS=0 EG=1.11
+ FC=0.5 IKF=12.5e-3 IKR=0 IRB=0 IS=6.58e-18 ISC=0 ISE=0 ISS=0 ITF=0 MJC=0.33
+ MJE=0.33 MJS=0 NC=2 NE=1.5 NF=1 NR=1 NS=1 PTF=0 RB=0 RBM=0 RC=0 RE=0 TF=1.59e-9
+ TR=0 TRB1=0 TRB2=0 TRC1=0 TRC2=0 TRE1=0 TRE2=0 TRM1=0 TRM2=0 VAF=100 VAR=0
+ VJC=0.75 VJE=0.75 VJS=0.75 VTF=0 XCJC=1 XTB=0 XTF=0 XTI=3 )
.ENDSYNTAX

.SYNTAX LTSPICE
.MODEL GENERATED_MODEL_QQ130 PNP( AF=0 BF=310 BR=1 CJC=3pf CJE=20pf CJS=0 EG=1.11
+ FC=0.5 IKF=12.5e-3 IKR=0 IRB=0 IS=6.58e-18 ISC=0 ISE=0 ISS=0 ITF=0 MJC=0.33
+ MJE=0.33 MJS=0 NC=2 NE=1.5 NF=1 NR=1 NS=1 PTF=0 RB=0 RBM=0 RC=0 RE=0 TF=1.59e-9
+ TR=0 TRB1=0 TRB2=0 TRC1=0 TRC2=0 TRE1=0 TRE2=0 TRM1=0 TRM2=0 VAF=100 VAR=0
+ VJC=0.75 VJE=0.75 VJS=0.75 VTF=0 XCJC=1 XTB=0 XTF=0 XTI=3 )
.ENDSYNTAX

.SYNTAX LTSPICE
.MODEL GENERATED_MODEL_QQ131 PNP( AF=0 BF=310 BR=1 CJC=3pf CJE=20pf CJS=0 EG=1.11
+ FC=0.5 IKF=12.5e-3 IKR=0 IRB=0 IS=6.58e-18 ISC=0 ISE=0 ISS=0 ITF=0 MJC=0.33
+ MJE=0.33 MJS=0 NC=2 NE=1.5 NF=1 NR=1 NS=1 PTF=0 RB=0 RBM=0 RC=0 RE=0 TF=1.59e-9
+ TR=0 TRB1=0 TRB2=0 TRC1=0 TRC2=0 TRE1=0 TRE2=0 TRM1=0 TRM2=0 VAF=100 VAR=0
+ VJC=0.75 VJE=0.75 VJS=0.75 VTF=0 XCJC=1 XTB=0 XTF=0 XTI=3 )
.ENDSYNTAX

.SYNTAX LTSPICE
.MODEL GENERATED_MODEL_QQ132 PNP( AF=0 BF=430 BR=3 CJC=2.5pf CJE=6pf CJS=0
+ EG=1.11 FC=0.5 IKF=25e-3 IKR=0 IRB=0 IS=1.43e-16 ISC=0 ISE=0 ISS=0 ITF=0 KF=0
+ MJC=0.33 MJE=0.33 MJS=0 NC=2 NE=1.5 NF=1 NR=1 NS=1 PTF=0 RB=0 RBM=0 RC=0 RE=0
+ TF=0 TR=0 TRB1=0 TRB2=0 TRC1=0 TRC2=0 TRE1=0 TRE2=0 TRM1=0 TRM2=0 VAF=50 VAR=0
+ VJC=0.75 VJE=0.75 VJS=0.75 VTF=0 XCJC=1 XTB=0 XTF=0 XTI=3 )
.ENDSYNTAX

.SYNTAX LTSPICE
.MODEL GENERATED_MODEL_QQ133 PNP( AF=0 BF=310 BR=1 CJC=3pf CJE=20pf CJS=0 EG=1.11
+ FC=0.5 IKF=12.5e-3 IKR=0 IRB=0 IS=6.58e-18 ISC=0 ISE=0 ISS=0 ITF=0 MJC=0.33
+ MJE=0.33 MJS=0 NC=2 NE=1.5 NF=1 NR=1 NS=1 PTF=0 RB=0 RBM=0 RC=0 RE=0 TF=1.59e-9
+ TR=0 TRB1=0 TRB2=0 TRC1=0 TRC2=0 TRE1=0 TRE2=0 TRM1=0 TRM2=0 VAF=100 VAR=0
+ VJC=0.75 VJE=0.75 VJS=0.75 VTF=0 XCJC=1 XTB=0 XTF=0 XTI=3 )
.ENDSYNTAX

.SYNTAX LTSPICE
.MODEL GENERATED_MODEL_QQ134 PNP( AF=0 BF=310 BR=1 CJC=3pf CJE=20pf CJS=0 EG=1.11
+ FC=0.5 IKF=12.5e-3 IKR=0 IRB=0 IS=6.58e-18 ISC=0 ISE=0 ISS=0 ITF=0 MJC=0.33
+ MJE=0.33 MJS=0 NC=2 NE=1.5 NF=1 NR=1 NS=1 PTF=0 RB=0 RBM=0 RC=0 RE=0 TF=1.59e-9
+ TR=0 TRB1=0 TRB2=0 TRC1=0 TRC2=0 TRE1=0 TRE2=0 TRM1=0 TRM2=0 VAF=100 VAR=0
+ VJC=0.75 VJE=0.75 VJS=0.75 VTF=0 XCJC=1 XTB=0 XTF=0 XTI=3 )
.ENDSYNTAX

.SYNTAX LTSPICE
.MODEL GENERATED_MODEL_QQ135 PNP( AF=0 BF=310 BR=1 CJC=3pf CJE=20pf CJS=0 EG=1.11
+ FC=0.5 IKF=12.5e-3 IKR=0 IRB=0 IS=6.58e-18 ISC=0 ISE=0 ISS=0 ITF=0 MJC=0.33
+ MJE=0.33 MJS=0 NC=2 NE=1.5 NF=1 NR=1 NS=1 PTF=0 RB=0 RBM=0 RC=0 RE=0 TF=1.59e-9
+ TR=0 TRB1=0 TRB2=0 TRC1=0 TRC2=0 TRE1=0 TRE2=0 TRM1=0 TRM2=0 VAF=100 VAR=0
+ VJC=0.75 VJE=0.75 VJS=0.75 VTF=0 XCJC=1 XTB=0 XTF=0 XTI=3 )
.ENDSYNTAX

.SYNTAX LTSPICE
.MODEL GENERATED_MODEL_QQ136 PNP( AF=0 BF=310 BR=1 CJC=3pf CJE=20pf CJS=0 EG=1.11
+ FC=0.5 IKF=12.5e-3 IKR=0 IRB=0 IS=6.58e-18 ISC=0 ISE=0 ISS=0 ITF=0 MJC=0.33
+ MJE=0.33 MJS=0 NC=2 NE=1.5 NF=1 NR=1 NS=1 PTF=0 RB=0 RBM=0 RC=0 RE=0 TF=1.59e-9
+ TR=0 TRB1=0 TRB2=0 TRC1=0 TRC2=0 TRE1=0 TRE2=0 TRM1=0 TRM2=0 VAF=100 VAR=0
+ VJC=0.75 VJE=0.75 VJS=0.75 VTF=0 XCJC=1 XTB=0 XTF=0 XTI=3 )
.ENDSYNTAX

.SYNTAX LTSPICE
.MODEL GENERATED_MODEL_QQ137 NPN( AF=0 BF=444 BR=3 CJC=2.5pf CJE=4pf CJS=0
+ EG=1.11 FC=0.5 IKF=25e-3 IKR=0 IRB=0 IS=1.43e-16 ISC=0 ISE=0 ISS=0 ITF=0 KF=0
+ MJC=0.33 MJE=0.33 MJS=0 NC=2 NE=1.5 NF=1 NR=1 NS=1 PTF=0 RB=0 RBM=0 RC=0 RE=0
+ TF=6.37e-10 TR=0 TRB1=0 TRB2=0 TRC1=0 TRC2=0 TRE1=0 TRE2=0 TRM1=0 TRM2=0 VAF=100
+ VAR=0 VJC=0.75 VJE=0.75 VJS=0.75 VTF=0 XCJC=1 XTB=0 XTF=0 XTI=3 )
.ENDSYNTAX

.SYNTAX LTSPICE
.MODEL GENERATED_MODEL_QQ138 PNP( AF=0 BF=310 BR=1 CJC=3pf CJE=20pf CJS=0 EG=1.11
+ FC=0.5 IKF=12.5e-3 IKR=0 IRB=0 IS=6.58e-18 ISC=0 ISE=0 ISS=0 ITF=0 MJC=0.33
+ MJE=0.33 MJS=0 NC=2 NE=1.5 NF=1 NR=1 NS=1 PTF=0 RB=0 RBM=0 RC=0 RE=0 TF=1.59e-9
+ TR=0 TRB1=0 TRB2=0 TRC1=0 TRC2=0 TRE1=0 TRE2=0 TRM1=0 TRM2=0 VAF=100 VAR=0
+ VJC=0.75 VJE=0.75 VJS=0.75 VTF=0 XCJC=1 XTB=0 XTF=0 XTI=3 )
.ENDSYNTAX

.SYNTAX LTSPICE
.MODEL GENERATED_MODEL_QQ139 PNP( AF=0 BF=310 BR=1 CJC=3pf CJE=20pf CJS=0 EG=1.11
+ FC=0.5 IKF=12.5e-3 IKR=0 IRB=0 IS=6.58e-18 ISC=0 ISE=0 ISS=0 ITF=0 MJC=0.33
+ MJE=0.33 MJS=0 NC=2 NE=1.5 NF=1 NR=1 NS=1 PTF=0 RB=0 RBM=0 RC=0 RE=0 TF=1.59e-9
+ TR=0 TRB1=0 TRB2=0 TRC1=0 TRC2=0 TRE1=0 TRE2=0 TRM1=0 TRM2=0 VAF=100 VAR=0
+ VJC=0.75 VJE=0.75 VJS=0.75 VTF=0 XCJC=1 XTB=0 XTF=0 XTI=3 )
.ENDSYNTAX

.SYNTAX LTSPICE
.MODEL GENERATED_MODEL_QQ141 NPN( AF=0 BF=444 BR=3 CJC=2.5pf CJE=4pf CJS=0
+ EG=1.11 FC=0.5 IKF=25e-3 IKR=0 IRB=0 IS=1.43e-16 ISC=0 ISE=0 ISS=0 ITF=0 KF=0
+ MJC=0.33 MJE=0.33 MJS=0 NC=2 NE=1.5 NF=1 NR=1 NS=1 PTF=0 RB=0 RBM=0 RC=0 RE=0
+ TF=6.37e-10 TR=0 TRB1=0 TRB2=0 TRC1=0 TRC2=0 TRE1=0 TRE2=0 TRM1=0 TRM2=0 VAF=100
+ VAR=0 VJC=0.75 VJE=0.75 VJS=0.75 VTF=0 XCJC=1 XTB=0 XTF=0 XTI=3 )
.ENDSYNTAX

.SYNTAX LTSPICE
.MODEL GENERATED_MODEL_QQ143 PNP( AF=0 BF=430 BR=3 CJC=2.5pf CJE=6pf CJS=0
+ EG=1.11 FC=0.5 IKF=25e-3 IKR=0 IRB=0 IS=1.43e-16 ISC=0 ISE=0 ISS=0 ITF=0 KF=0
+ MJC=0.33 MJE=0.33 MJS=0 NC=2 NE=1.5 NF=1 NR=1 NS=1 PTF=0 RB=0 RBM=0 RC=0 RE=0
+ TF=0 TR=0 TRB1=0 TRB2=0 TRC1=0 TRC2=0 TRE1=0 TRE2=0 TRM1=0 TRM2=0 VAF=50 VAR=0
+ VJC=0.75 VJE=0.75 VJS=0.75 VTF=0 XCJC=1 XTB=0 XTF=0 XTI=3 )
.ENDSYNTAX

.SYNTAX LTSPICE
.MODEL GENERATED_MODEL_QQ146 PNP( AF=0 BF=430 BR=3 CJC=2.5pf CJE=6pf CJS=0
+ EG=1.11 FC=0.5 IKF=25e-3 IKR=0 IRB=0 IS=1.43e-16 ISC=0 ISE=0 ISS=0 ITF=0 KF=0
+ MJC=0.33 MJE=0.33 MJS=0 NC=2 NE=1.5 NF=1 NR=1 NS=1 PTF=0 RB=0 RBM=0 RC=0 RE=0
+ TF=0 TR=0 TRB1=0 TRB2=0 TRC1=0 TRC2=0 TRE1=0 TRE2=0 TRM1=0 TRM2=0 VAF=50 VAR=0
+ VJC=0.75 VJE=0.75 VJS=0.75 VTF=0 XCJC=1 XTB=0 XTF=0 XTI=3 )
.ENDSYNTAX

.SYNTAX LTSPICE
.MODEL GENERATED_MODEL_QQ147 PNP( AF=0 BF=310 BR=1 CJC=3pf CJE=20pf CJS=0 EG=1.11
+ FC=0.5 IKF=12.5e-3 IKR=0 IRB=0 IS=6.58e-18 ISC=0 ISE=0 ISS=0 ITF=0 MJC=0.33
+ MJE=0.33 MJS=0 NC=2 NE=1.5 NF=1 NR=1 NS=1 PTF=0 RB=0 RBM=0 RC=0 RE=0 TF=1.59e-9
+ TR=0 TRB1=0 TRB2=0 TRC1=0 TRC2=0 TRE1=0 TRE2=0 TRM1=0 TRM2=0 VAF=100 VAR=0
+ VJC=0.75 VJE=0.75 VJS=0.75 VTF=0 XCJC=1 XTB=0 XTF=0 XTI=3 )
.ENDSYNTAX

.SYNTAX LTSPICE
.MODEL GENERATED_MODEL_QQ148 PNP( AF=0 BF=310 BR=1 CJC=3pf CJE=20pf CJS=0 EG=1.11
+ FC=0.5 IKF=12.5e-3 IKR=0 IRB=0 IS=6.58e-18 ISC=0 ISE=0 ISS=0 ITF=0 MJC=0.33
+ MJE=0.33 MJS=0 NC=2 NE=1.5 NF=1 NR=1 NS=1 PTF=0 RB=0 RBM=0 RC=0 RE=0 TF=1.59e-9
+ TR=0 TRB1=0 TRB2=0 TRC1=0 TRC2=0 TRE1=0 TRE2=0 TRM1=0 TRM2=0 VAF=100 VAR=0
+ VJC=0.75 VJE=0.75 VJS=0.75 VTF=0 XCJC=1 XTB=0 XTF=0 XTI=3 )
.ENDSYNTAX

.SYNTAX LTSPICE
.MODEL GENERATED_MODEL_QQ149 PNP( AF=0 BF=310 BR=1 CJC=3pf CJE=20pf CJS=0 EG=1.11
+ FC=0.5 IKF=12.5e-3 IKR=0 IRB=0 IS=6.58e-18 ISC=0 ISE=0 ISS=0 ITF=0 MJC=0.33
+ MJE=0.33 MJS=0 NC=2 NE=1.5 NF=1 NR=1 NS=1 PTF=0 RB=0 RBM=0 RC=0 RE=0 TF=1.59e-9
+ TR=0 TRB1=0 TRB2=0 TRC1=0 TRC2=0 TRE1=0 TRE2=0 TRM1=0 TRM2=0 VAF=100 VAR=0
+ VJC=0.75 VJE=0.75 VJS=0.75 VTF=0 XCJC=1 XTB=0 XTF=0 XTI=3 )
.ENDSYNTAX

.SYNTAX LTSPICE
.MODEL GENERATED_MODEL_QQ150 NPN( AF=0 BF=320 BR=1 CJC=3.7pf CJE=13pf CJS=0
+ EG=1.11 FC=0.5 IKF=12.5e-3 IKR=0 IRB=0 IS=6.58e-18 ISC=0 ISE=0 ISS=0 ITF=0 KF=0
+ MJC=0.33 MJE=0.33 MJS=0 NC=2 NE=1.5 NF=1 NR=1 NS=1 PTF=0 RB=0 RBM=0 RC=0 RE=0
+ TF=1.44e-9 TNOM=27 TR=0 TRB1=0 TRB2=0 TRC1=0 TRC2=0 TRE1=0 TRE2=0 TRM1=0 TRM2=0
+ VAF=150 VAR=0 VJC=0.75 VJE=0.75 VJS=0.75 VTF=0 XCJC=1 XTB=0 XTF=0 XTI=3 )
.ENDSYNTAX

.SYNTAX LTSPICE
.MODEL GENERATED_MODEL_QQ151 NPN( AF=0 BF=320 BR=1 CJC=3.7pf CJE=13pf CJS=0
+ EG=1.11 FC=0.5 IKF=12.5e-3 IKR=0 IRB=0 IS=6.58e-18 ISC=0 ISE=0 ISS=0 ITF=0 KF=0
+ MJC=0.33 MJE=0.33 MJS=0 NC=2 NE=1.5 NF=1 NR=1 NS=1 PTF=0 RB=0 RBM=0 RC=0 RE=0
+ TF=1.44e-9 TNOM=27 TR=0 TRB1=0 TRB2=0 TRC1=0 TRC2=0 TRE1=0 TRE2=0 TRM1=0 TRM2=0
+ VAF=150 VAR=0 VJC=0.75 VJE=0.75 VJS=0.75 VTF=0 XCJC=1 XTB=0 XTF=0 XTI=3 )
.ENDSYNTAX

.SYNTAX LTSPICE
.MODEL GENERATED_MODEL_QQ152 NPN( AF=0 BF=320 BR=1 CJC=3.7pf CJE=13pf CJS=0
+ EG=1.11 FC=0.5 IKF=12.5e-3 IKR=0 IRB=0 IS=6.58e-18 ISC=0 ISE=0 ISS=0 ITF=0 KF=0
+ MJC=0.33 MJE=0.33 MJS=0 NC=2 NE=1.5 NF=1 NR=1 NS=1 PTF=0 RB=0 RBM=0 RC=0 RE=0
+ TF=1.44e-9 TNOM=27 TR=0 TRB1=0 TRB2=0 TRC1=0 TRC2=0 TRE1=0 TRE2=0 TRM1=0 TRM2=0
+ VAF=150 VAR=0 VJC=0.75 VJE=0.75 VJS=0.75 VTF=0 XCJC=1 XTB=0 XTF=0 XTI=3 )
.ENDSYNTAX

.SYNTAX LTSPICE
.MODEL GENERATED_MODEL_QQ153 PNP( AF=0 BF=310 BR=1 CJC=3pf CJE=20pf CJS=0 EG=1.11
+ FC=0.5 IKF=12.5e-3 IKR=0 IRB=0 IS=6.58e-18 ISC=0 ISE=0 ISS=0 ITF=0 MJC=0.33
+ MJE=0.33 MJS=0 NC=2 NE=1.5 NF=1 NR=1 NS=1 PTF=0 RB=0 RBM=0 RC=0 RE=0 TF=1.59e-9
+ TR=0 TRB1=0 TRB2=0 TRC1=0 TRC2=0 TRE1=0 TRE2=0 TRM1=0 TRM2=0 VAF=100 VAR=0
+ VJC=0.75 VJE=0.75 VJS=0.75 VTF=0 XCJC=1 XTB=0 XTF=0 XTI=3 )
.ENDSYNTAX

.SYNTAX LTSPICE
.MODEL GENERATED_MODEL_QQ154 PNP( AF=0 BF=310 BR=1 CJC=3pf CJE=20pf CJS=0 EG=1.11
+ FC=0.5 IKF=12.5e-3 IKR=0 IRB=0 IS=6.58e-18 ISC=0 ISE=0 ISS=0 ITF=0 MJC=0.33
+ MJE=0.33 MJS=0 NC=2 NE=1.5 NF=1 NR=1 NS=1 PTF=0 RB=0 RBM=0 RC=0 RE=0 TF=1.59e-9
+ TR=0 TRB1=0 TRB2=0 TRC1=0 TRC2=0 TRE1=0 TRE2=0 TRM1=0 TRM2=0 VAF=100 VAR=0
+ VJC=0.75 VJE=0.75 VJS=0.75 VTF=0 XCJC=1 XTB=0 XTF=0 XTI=3 )
.ENDSYNTAX

.SYNTAX LTSPICE
.MODEL GENERATED_MODEL_QQ155 PNP( AF=0 BF=310 BR=1 CJC=3pf CJE=20pf CJS=0 EG=1.11
+ FC=0.5 IKF=12.5e-3 IKR=0 IRB=0 IS=6.58e-18 ISC=0 ISE=0 ISS=0 ITF=0 MJC=0.33
+ MJE=0.33 MJS=0 NC=2 NE=1.5 NF=1 NR=1 NS=1 PTF=0 RB=0 RBM=0 RC=0 RE=0 TF=1.59e-9
+ TR=0 TRB1=0 TRB2=0 TRC1=0 TRC2=0 TRE1=0 TRE2=0 TRM1=0 TRM2=0 VAF=100 VAR=0
+ VJC=0.75 VJE=0.75 VJS=0.75 VTF=0 XCJC=1 XTB=0 XTF=0 XTI=3 )
.ENDSYNTAX

.SYNTAX LTSPICE
.MODEL GENERATED_MODEL_QQ156 PNP( AF=0 BF=310 BR=1 CJC=3pf CJE=20pf CJS=0 EG=1.11
+ FC=0.5 IKF=12.5e-3 IKR=0 IRB=0 IS=6.58e-18 ISC=0 ISE=0 ISS=0 ITF=0 MJC=0.33
+ MJE=0.33 MJS=0 NC=2 NE=1.5 NF=1 NR=1 NS=1 PTF=0 RB=0 RBM=0 RC=0 RE=0 TF=1.59e-9
+ TR=0 TRB1=0 TRB2=0 TRC1=0 TRC2=0 TRE1=0 TRE2=0 TRM1=0 TRM2=0 VAF=100 VAR=0
+ VJC=0.75 VJE=0.75 VJS=0.75 VTF=0 XCJC=1 XTB=0 XTF=0 XTI=3 )
.ENDSYNTAX

.SYNTAX LTSPICE
.MODEL GENERATED_MODEL_QQ157 PNP( AF=0 BF=310 BR=1 CJC=3pf CJE=20pf CJS=0 EG=1.11
+ FC=0.5 IKF=12.5e-3 IKR=0 IRB=0 IS=6.58e-18 ISC=0 ISE=0 ISS=0 ITF=0 MJC=0.33
+ MJE=0.33 MJS=0 NC=2 NE=1.5 NF=1 NR=1 NS=1 PTF=0 RB=0 RBM=0 RC=0 RE=0 TF=1.59e-9
+ TR=0 TRB1=0 TRB2=0 TRC1=0 TRC2=0 TRE1=0 TRE2=0 TRM1=0 TRM2=0 VAF=100 VAR=0
+ VJC=0.75 VJE=0.75 VJS=0.75 VTF=0 XCJC=1 XTB=0 XTF=0 XTI=3 )
.ENDSYNTAX

.SYNTAX LTSPICE
.MODEL GENERATED_MODEL_QQ158 NPN( AF=0 BF=320 BR=1 CJC=3.7pf CJE=13pf CJS=0
+ EG=1.11 FC=0.5 IKF=12.5e-3 IKR=0 IRB=0 IS=6.58e-18 ISC=0 ISE=0 ISS=0 ITF=0 KF=0
+ MJC=0.33 MJE=0.33 MJS=0 NC=2 NE=1.5 NF=1 NR=1 NS=1 PTF=0 RB=0 RBM=0 RC=0 RE=0
+ TF=1.44e-9 TNOM=27 TR=0 TRB1=0 TRB2=0 TRC1=0 TRC2=0 TRE1=0 TRE2=0 TRM1=0 TRM2=0
+ VAF=150 VAR=0 VJC=0.75 VJE=0.75 VJS=0.75 VTF=0 XCJC=1 XTB=0 XTF=0 XTI=3 )
.ENDSYNTAX

.SYNTAX LTSPICE
.MODEL GENERATED_MODEL_QQ159 NPN( AF=0 BF=320 BR=1 CJC=3.7pf CJE=13pf CJS=0
+ EG=1.11 FC=0.5 IKF=12.5e-3 IKR=0 IRB=0 IS=6.58e-18 ISC=0 ISE=0 ISS=0 ITF=0 KF=0
+ MJC=0.33 MJE=0.33 MJS=0 NC=2 NE=1.5 NF=1 NR=1 NS=1 PTF=0 RB=0 RBM=0 RC=0 RE=0
+ TF=1.44e-9 TNOM=27 TR=0 TRB1=0 TRB2=0 TRC1=0 TRC2=0 TRE1=0 TRE2=0 TRM1=0 TRM2=0
+ VAF=150 VAR=0 VJC=0.75 VJE=0.75 VJS=0.75 VTF=0 XCJC=1 XTB=0 XTF=0 XTI=3 )
.ENDSYNTAX

.SYNTAX LTSPICE
.MODEL GENERATED_MODEL_QQ160 NPN( AF=0 BF=320 BR=1 CJC=3.7pf CJE=13pf CJS=0
+ EG=1.11 FC=0.5 IKF=12.5e-3 IKR=0 IRB=0 IS=6.58e-18 ISC=0 ISE=0 ISS=0 ITF=0 KF=0
+ MJC=0.33 MJE=0.33 MJS=0 NC=2 NE=1.5 NF=1 NR=1 NS=1 PTF=0 RB=0 RBM=0 RC=0 RE=0
+ TF=1.44e-9 TNOM=27 TR=0 TRB1=0 TRB2=0 TRC1=0 TRC2=0 TRE1=0 TRE2=0 TRM1=0 TRM2=0
+ VAF=150 VAR=0 VJC=0.75 VJE=0.75 VJS=0.75 VTF=0 XCJC=1 XTB=0 XTF=0 XTI=3 )
.ENDSYNTAX

.SYNTAX LTSPICE
.MODEL GENERATED_MODEL_QQ161 PNP( AF=0 BF=310 BR=1 CJC=3pf CJE=20pf CJS=0 EG=1.11
+ FC=0.5 IKF=12.5e-3 IKR=0 IRB=0 IS=6.58e-18 ISC=0 ISE=0 ISS=0 ITF=0 MJC=0.33
+ MJE=0.33 MJS=0 NC=2 NE=1.5 NF=1 NR=1 NS=1 PTF=0 RB=0 RBM=0 RC=0 RE=0 TF=1.59e-9
+ TR=0 TRB1=0 TRB2=0 TRC1=0 TRC2=0 TRE1=0 TRE2=0 TRM1=0 TRM2=0 VAF=100 VAR=0
+ VJC=0.75 VJE=0.75 VJS=0.75 VTF=0 XCJC=1 XTB=0 XTF=0 XTI=3 )
.ENDSYNTAX

.SYNTAX LTSPICE
.MODEL GENERATED_MODEL_QQ162 PNP( AF=0 BF=430 BR=3 CJC=2.5pf CJE=6pf CJS=0
+ EG=1.11 FC=0.5 IKF=25e-3 IKR=0 IRB=0 IS=1.43e-16 ISC=0 ISE=0 ISS=0 ITF=0 KF=0
+ MJC=0.33 MJE=0.33 MJS=0 NC=2 NE=1.5 NF=1 NR=1 NS=1 PTF=0 RB=0 RBM=0 RC=0 RE=0
+ TF=0 TR=0 TRB1=0 TRB2=0 TRC1=0 TRC2=0 TRE1=0 TRE2=0 TRM1=0 TRM2=0 VAF=50 VAR=0
+ VJC=0.75 VJE=0.75 VJS=0.75 VTF=0 XCJC=1 XTB=0 XTF=0 XTI=3 )
.ENDSYNTAX

.SYNTAX LTSPICE
.MODEL GENERATED_MODEL_QQ164 PNP( AF=0 BF=310 BR=1 CJC=3pf CJE=20pf CJS=0 EG=1.11
+ FC=0.5 IKF=12.5e-3 IKR=0 IRB=0 IS=6.58e-18 ISC=0 ISE=0 ISS=0 ITF=0 MJC=0.33
+ MJE=0.33 MJS=0 NC=2 NE=1.5 NF=1 NR=1 NS=1 PTF=0 RB=0 RBM=0 RC=0 RE=0 TF=1.59e-9
+ TR=0 TRB1=0 TRB2=0 TRC1=0 TRC2=0 TRE1=0 TRE2=0 TRM1=0 TRM2=0 VAF=100 VAR=0
+ VJC=0.75 VJE=0.75 VJS=0.75 VTF=0 XCJC=1 XTB=0 XTF=0 XTI=3 )
.ENDSYNTAX

.SYNTAX LTSPICE
.MODEL GENERATED_MODEL_QQ165 PNP( AF=0 BF=310 BR=1 CJC=3pf CJE=20pf CJS=0 EG=1.11
+ FC=0.5 IKF=12.5e-3 IKR=0 IRB=0 IS=6.58e-18 ISC=0 ISE=0 ISS=0 ITF=0 MJC=0.33
+ MJE=0.33 MJS=0 NC=2 NE=1.5 NF=1 NR=1 NS=1 PTF=0 RB=0 RBM=0 RC=0 RE=0 TF=1.59e-9
+ TR=0 TRB1=0 TRB2=0 TRC1=0 TRC2=0 TRE1=0 TRE2=0 TRM1=0 TRM2=0 VAF=100 VAR=0
+ VJC=0.75 VJE=0.75 VJS=0.75 VTF=0 XCJC=1 XTB=0 XTF=0 XTI=3 )
.ENDSYNTAX

.SYNTAX LTSPICE
.MODEL GENERATED_MODEL_QQ166 NPN( AF=0 BF=320 BR=1 CJC=3.7pf CJE=13pf CJS=0
+ EG=1.11 FC=0.5 IKF=12.5e-3 IKR=0 IRB=0 IS=6.58e-18 ISC=0 ISE=0 ISS=0 ITF=0 KF=0
+ MJC=0.33 MJE=0.33 MJS=0 NC=2 NE=1.5 NF=1 NR=1 NS=1 PTF=0 RB=0 RBM=0 RC=0 RE=0
+ TF=1.44e-9 TNOM=27 TR=0 TRB1=0 TRB2=0 TRC1=0 TRC2=0 TRE1=0 TRE2=0 TRM1=0 TRM2=0
+ VAF=150 VAR=0 VJC=0.75 VJE=0.75 VJS=0.75 VTF=0 XCJC=1 XTB=0 XTF=0 XTI=3 )
.ENDSYNTAX

.SYNTAX LTSPICE
.MODEL GENERATED_MODEL_QQ169 PNP( AF=0 BF=430 BR=3 CJC=2.5pf CJE=6pf CJS=0
+ EG=1.11 FC=0.5 IKF=25e-3 IKR=0 IRB=0 IS=1.43e-16 ISC=0 ISE=0 ISS=0 ITF=0 KF=0
+ MJC=0.33 MJE=0.33 MJS=0 NC=2 NE=1.5 NF=1 NR=1 NS=1 PTF=0 RB=0 RBM=0 RC=0 RE=0
+ TF=0 TR=0 TRB1=0 TRB2=0 TRC1=0 TRC2=0 TRE1=0 TRE2=0 TRM1=0 TRM2=0 VAF=50 VAR=0
+ VJC=0.75 VJE=0.75 VJS=0.75 VTF=0 XCJC=1 XTB=0 XTF=0 XTI=3 )
.ENDSYNTAX

.SYNTAX LTSPICE
.MODEL GENERATED_MODEL_QQ170 NPN( AF=0 BF=444 BR=3 CJC=2.5pf CJE=4pf CJS=0
+ EG=1.11 FC=0.5 IKF=25e-3 IKR=0 IRB=0 IS=1.43e-16 ISC=0 ISE=0 ISS=0 ITF=0 KF=0
+ MJC=0.33 MJE=0.33 MJS=0 NC=2 NE=1.5 NF=1 NR=1 NS=1 PTF=0 RB=0 RBM=0 RC=0 RE=0
+ TF=6.37e-10 TR=0 TRB1=0 TRB2=0 TRC1=0 TRC2=0 TRE1=0 TRE2=0 TRM1=0 TRM2=0 VAF=100
+ VAR=0 VJC=0.75 VJE=0.75 VJS=0.75 VTF=0 XCJC=1 XTB=0 XTF=0 XTI=3 )
.ENDSYNTAX

.SYNTAX LTSPICE
.MODEL GENERATED_MODEL_QQ171 NPN( AF=0 BF=444 BR=3 CJC=2.5pf CJE=4pf CJS=0
+ EG=1.11 FC=0.5 IKF=25e-3 IKR=0 IRB=0 IS=1.43e-16 ISC=0 ISE=0 ISS=0 ITF=0 KF=0
+ MJC=0.33 MJE=0.33 MJS=0 NC=2 NE=1.5 NF=1 NR=1 NS=1 PTF=0 RB=0 RBM=0 RC=0 RE=0
+ TF=6.37e-10 TR=0 TRB1=0 TRB2=0 TRC1=0 TRC2=0 TRE1=0 TRE2=0 TRM1=0 TRM2=0 VAF=100
+ VAR=0 VJC=0.75 VJE=0.75 VJS=0.75 VTF=0 XCJC=1 XTB=0 XTF=0 XTI=3 )
.ENDSYNTAX

.SYNTAX LTSPICE
.MODEL GENERATED_MODEL_QQ172 NPN( AF=0 BF=320 BR=1 CJC=3.7pf CJE=13pf CJS=0
+ EG=1.11 FC=0.5 IKF=12.5e-3 IKR=0 IRB=0 IS=6.58e-18 ISC=0 ISE=0 ISS=0 ITF=0 KF=0
+ MJC=0.33 MJE=0.33 MJS=0 NC=2 NE=1.5 NF=1 NR=1 NS=1 PTF=0 RB=0 RBM=0 RC=0 RE=0
+ TF=1.44e-9 TNOM=27 TR=0 TRB1=0 TRB2=0 TRC1=0 TRC2=0 TRE1=0 TRE2=0 TRM1=0 TRM2=0
+ VAF=150 VAR=0 VJC=0.75 VJE=0.75 VJS=0.75 VTF=0 XCJC=1 XTB=0 XTF=0 XTI=3 )
.ENDSYNTAX

.SYNTAX LTSPICE
.MODEL GENERATED_MODEL_QQ176 NPN( AF=0 BF=320 BR=1 CJC=3.7pf CJE=13pf CJS=0
+ EG=1.11 FC=0.5 IKF=12.5e-3 IKR=0 IRB=0 IS=6.58e-18 ISC=0 ISE=0 ISS=0 ITF=0 KF=0
+ MJC=0.33 MJE=0.33 MJS=0 NC=2 NE=1.5 NF=1 NR=1 NS=1 PTF=0 RB=0 RBM=0 RC=0 RE=0
+ TF=1.44e-9 TNOM=27 TR=0 TRB1=0 TRB2=0 TRC1=0 TRC2=0 TRE1=0 TRE2=0 TRM1=0 TRM2=0
+ VAF=150 VAR=0 VJC=0.75 VJE=0.75 VJS=0.75 VTF=0 XCJC=1 XTB=0 XTF=0 XTI=3 )
.ENDSYNTAX

.SYNTAX LTSPICE
.MODEL GENERATED_MODEL_QQ177 NPN( AF=0 BF=320 BR=1 CJC=3.7pf CJE=13pf CJS=0
+ EG=1.11 FC=0.5 IKF=12.5e-3 IKR=0 IRB=0 IS=6.58e-18 ISC=0 ISE=0 ISS=0 ITF=0 KF=0
+ MJC=0.33 MJE=0.33 MJS=0 NC=2 NE=1.5 NF=1 NR=1 NS=1 PTF=0 RB=0 RBM=0 RC=0 RE=0
+ TF=1.44e-9 TNOM=27 TR=0 TRB1=0 TRB2=0 TRC1=0 TRC2=0 TRE1=0 TRE2=0 TRM1=0 TRM2=0
+ VAF=150 VAR=0 VJC=0.75 VJE=0.75 VJS=0.75 VTF=0 XCJC=1 XTB=0 XTF=0 XTI=3 )
.ENDSYNTAX

.SYNTAX LTSPICE
.MODEL GENERATED_MODEL_QQ179 NPN( AF=0 BF=320 BR=1 CJC=3.7pf CJE=13pf CJS=0
+ EG=1.11 FC=0.5 IKF=12.5e-3 IKR=0 IRB=0 IS=6.58e-18 ISC=0 ISE=0 ISS=0 ITF=0 KF=0
+ MJC=0.33 MJE=0.33 MJS=0 NC=2 NE=1.5 NF=1 NR=1 NS=1 PTF=0 RB=0 RBM=0 RC=0 RE=0
+ TF=1.44e-9 TNOM=27 TR=0 TRB1=0 TRB2=0 TRC1=0 TRC2=0 TRE1=0 TRE2=0 TRM1=0 TRM2=0
+ VAF=150 VAR=0 VJC=0.75 VJE=0.75 VJS=0.75 VTF=0 XCJC=1 XTB=0 XTF=0 XTI=3 )
.ENDSYNTAX

.SYNTAX LTSPICE
.MODEL GENERATED_MODEL_QQ180 NPN( AF=0 BF=320 BR=1 CJC=3.7pf CJE=13pf CJS=0
+ EG=1.11 FC=0.5 IKF=12.5e-3 IKR=0 IRB=0 IS=6.58e-18 ISC=0 ISE=0 ISS=0 ITF=0 KF=0
+ MJC=0.33 MJE=0.33 MJS=0 NC=2 NE=1.5 NF=1 NR=1 NS=1 PTF=0 RB=0 RBM=0 RC=0 RE=0
+ TF=1.44e-9 TNOM=27 TR=0 TRB1=0 TRB2=0 TRC1=0 TRC2=0 TRE1=0 TRE2=0 TRM1=0 TRM2=0
+ VAF=150 VAR=0 VJC=0.75 VJE=0.75 VJS=0.75 VTF=0 XCJC=1 XTB=0 XTF=0 XTI=3 )
.ENDSYNTAX

.SYNTAX LTSPICE
.MODEL GENERATED_MODEL_QQ182 NPN( AF=0 BF=320 BR=1 CJC=3.7pf CJE=13pf CJS=0
+ EG=1.11 FC=0.5 IKF=12.5e-3 IKR=0 IRB=0 IS=6.58e-18 ISC=0 ISE=0 ISS=0 ITF=0 KF=0
+ MJC=0.33 MJE=0.33 MJS=0 NC=2 NE=1.5 NF=1 NR=1 NS=1 PTF=0 RB=0 RBM=0 RC=0 RE=0
+ TF=1.44e-9 TNOM=27 TR=0 TRB1=0 TRB2=0 TRC1=0 TRC2=0 TRE1=0 TRE2=0 TRM1=0 TRM2=0
+ VAF=150 VAR=0 VJC=0.75 VJE=0.75 VJS=0.75 VTF=0 XCJC=1 XTB=0 XTF=0 XTI=3 )
.ENDSYNTAX

.SYNTAX LTSPICE
.MODEL GENERATED_MODEL_QQ183 NPN( AF=0 BF=320 BR=1 CJC=3.7pf CJE=13pf CJS=0
+ EG=1.11 FC=0.5 IKF=12.5e-3 IKR=0 IRB=0 IS=6.58e-18 ISC=0 ISE=0 ISS=0 ITF=0 KF=0
+ MJC=0.33 MJE=0.33 MJS=0 NC=2 NE=1.5 NF=1 NR=1 NS=1 PTF=0 RB=0 RBM=0 RC=0 RE=0
+ TF=1.44e-9 TNOM=27 TR=0 TRB1=0 TRB2=0 TRC1=0 TRC2=0 TRE1=0 TRE2=0 TRM1=0 TRM2=0
+ VAF=150 VAR=0 VJC=0.75 VJE=0.75 VJS=0.75 VTF=0 XCJC=1 XTB=0 XTF=0 XTI=3 )
.ENDSYNTAX

.SYNTAX LTSPICE
.MODEL GENERATED_MODEL_QQ186 NPN( AF=0 BF=320 BR=1 CJC=3.7pf CJE=13pf CJS=0
+ EG=1.11 FC=0.5 IKF=12.5e-3 IKR=0 IRB=0 IS=6.58e-18 ISC=0 ISE=0 ISS=0 ITF=0 KF=0
+ MJC=0.33 MJE=0.33 MJS=0 NC=2 NE=1.5 NF=1 NR=1 NS=1 PTF=0 RB=0 RBM=0 RC=0 RE=0
+ TF=1.44e-9 TNOM=27 TR=0 TRB1=0 TRB2=0 TRC1=0 TRC2=0 TRE1=0 TRE2=0 TRM1=0 TRM2=0
+ VAF=150 VAR=0 VJC=0.75 VJE=0.75 VJS=0.75 VTF=0 XCJC=1 XTB=0 XTF=0 XTI=3 )
.ENDSYNTAX

.SYNTAX LTSPICE
.MODEL GENERATED_MODEL_QQ189 NPN( AF=0 BF=320 BR=1 CJC=3.7pf CJE=13pf CJS=0
+ EG=1.11 FC=0.5 IKF=12.5e-3 IKR=0 IRB=0 IS=6.58e-18 ISC=0 ISE=0 ISS=0 ITF=0 KF=0
+ MJC=0.33 MJE=0.33 MJS=0 NC=2 NE=1.5 NF=1 NR=1 NS=1 PTF=0 RB=0 RBM=0 RC=0 RE=0
+ TF=1.44e-9 TNOM=27 TR=0 TRB1=0 TRB2=0 TRC1=0 TRC2=0 TRE1=0 TRE2=0 TRM1=0 TRM2=0
+ VAF=150 VAR=0 VJC=0.75 VJE=0.75 VJS=0.75 VTF=0 XCJC=1 XTB=0 XTF=0 XTI=3 )
.ENDSYNTAX

.SYNTAX LTSPICE
.MODEL GENERATED_MODEL_QQ190 NPN( AF=0 BF=320 BR=1 CJC=3.7pf CJE=13pf CJS=0
+ EG=1.11 FC=0.5 IKF=12.5e-3 IKR=0 IRB=0 IS=6.58e-18 ISC=0 ISE=0 ISS=0 ITF=0 KF=0
+ MJC=0.33 MJE=0.33 MJS=0 NC=2 NE=1.5 NF=1 NR=1 NS=1 PTF=0 RB=0 RBM=0 RC=0 RE=0
+ TF=1.44e-9 TNOM=27 TR=0 TRB1=0 TRB2=0 TRC1=0 TRC2=0 TRE1=0 TRE2=0 TRM1=0 TRM2=0
+ VAF=150 VAR=0 VJC=0.75 VJE=0.75 VJS=0.75 VTF=0 XCJC=1 XTB=0 XTF=0 XTI=3 )
.ENDSYNTAX

.SYNTAX LTSPICE
.MODEL GENERATED_MODEL_QQ192 NPN( AF=0 BF=320 BR=1 CJC=3.7pf CJE=13pf CJS=0
+ EG=1.11 FC=0.5 IKF=12.5e-3 IKR=0 IRB=0 IS=6.58e-18 ISC=0 ISE=0 ISS=0 ITF=0 KF=0
+ MJC=0.33 MJE=0.33 MJS=0 NC=2 NE=1.5 NF=1 NR=1 NS=1 PTF=0 RB=0 RBM=0 RC=0 RE=0
+ TF=1.44e-9 TNOM=27 TR=0 TRB1=0 TRB2=0 TRC1=0 TRC2=0 TRE1=0 TRE2=0 TRM1=0 TRM2=0
+ VAF=150 VAR=0 VJC=0.75 VJE=0.75 VJS=0.75 VTF=0 XCJC=1 XTB=0 XTF=0 XTI=3 )
.ENDSYNTAX

.SYNTAX LTSPICE
.MODEL GENERATED_MODEL_QQ193 NPN( AF=0 BF=320 BR=1 CJC=3.7pf CJE=13pf CJS=0
+ EG=1.11 FC=0.5 IKF=12.5e-3 IKR=0 IRB=0 IS=6.58e-18 ISC=0 ISE=0 ISS=0 ITF=0 KF=0
+ MJC=0.33 MJE=0.33 MJS=0 NC=2 NE=1.5 NF=1 NR=1 NS=1 PTF=0 RB=0 RBM=0 RC=0 RE=0
+ TF=1.44e-9 TNOM=27 TR=0 TRB1=0 TRB2=0 TRC1=0 TRC2=0 TRE1=0 TRE2=0 TRM1=0 TRM2=0
+ VAF=150 VAR=0 VJC=0.75 VJE=0.75 VJS=0.75 VTF=0 XCJC=1 XTB=0 XTF=0 XTI=3 )
.ENDSYNTAX

.SYNTAX LTSPICE
.MODEL GENERATED_MODEL_QQ194 NPN( AF=0 BF=320 BR=1 CJC=3.7pf CJE=13pf CJS=0
+ EG=1.11 FC=0.5 IKF=12.5e-3 IKR=0 IRB=0 IS=6.58e-18 ISC=0 ISE=0 ISS=0 ITF=0 KF=0
+ MJC=0.33 MJE=0.33 MJS=0 NC=2 NE=1.5 NF=1 NR=1 NS=1 PTF=0 RB=0 RBM=0 RC=0 RE=0
+ TF=1.44e-9 TNOM=27 TR=0 TRB1=0 TRB2=0 TRC1=0 TRC2=0 TRE1=0 TRE2=0 TRM1=0 TRM2=0
+ VAF=150 VAR=0 VJC=0.75 VJE=0.75 VJS=0.75 VTF=0 XCJC=1 XTB=0 XTF=0 XTI=3 )
.ENDSYNTAX

.SYNTAX LTSPICE
.MODEL GENERATED_MODEL_QQ195 NPN( AF=0 BF=320 BR=1 CJC=3.7pf CJE=13pf CJS=0
+ EG=1.11 FC=0.5 IKF=12.5e-3 IKR=0 IRB=0 IS=6.58e-18 ISC=0 ISE=0 ISS=0 ITF=0 KF=0
+ MJC=0.33 MJE=0.33 MJS=0 NC=2 NE=1.5 NF=1 NR=1 NS=1 PTF=0 RB=0 RBM=0 RC=0 RE=0
+ TF=1.44e-9 TNOM=27 TR=0 TRB1=0 TRB2=0 TRC1=0 TRC2=0 TRE1=0 TRE2=0 TRM1=0 TRM2=0
+ VAF=150 VAR=0 VJC=0.75 VJE=0.75 VJS=0.75 VTF=0 XCJC=1 XTB=0 XTF=0 XTI=3 )
.ENDSYNTAX

.SYNTAX LTSPICE
.MODEL GENERATED_MODEL_QQ197 NPN( AF=0 BF=320 BR=1 CJC=3.7pf CJE=13pf CJS=0
+ EG=1.11 FC=0.5 IKF=12.5e-3 IKR=0 IRB=0 IS=6.58e-18 ISC=0 ISE=0 ISS=0 ITF=0 KF=0
+ MJC=0.33 MJE=0.33 MJS=0 NC=2 NE=1.5 NF=1 NR=1 NS=1 PTF=0 RB=0 RBM=0 RC=0 RE=0
+ TF=1.44e-9 TNOM=27 TR=0 TRB1=0 TRB2=0 TRC1=0 TRC2=0 TRE1=0 TRE2=0 TRM1=0 TRM2=0
+ VAF=150 VAR=0 VJC=0.75 VJE=0.75 VJS=0.75 VTF=0 XCJC=1 XTB=0 XTF=0 XTI=3 )
.ENDSYNTAX

.SYNTAX LTSPICE
.MODEL GENERATED_MODEL_QQ199 NPN( AF=0 BF=444 BR=3 CJC=2.5pf CJE=4pf CJS=0
+ EG=1.11 FC=0.5 IKF=25e-3 IKR=0 IRB=0 IS=1.43e-16 ISC=0 ISE=0 ISS=0 ITF=0 KF=0
+ MJC=0.33 MJE=0.33 MJS=0 NC=2 NE=1.5 NF=1 NR=1 NS=1 PTF=0 RB=0 RBM=0 RC=0 RE=0
+ TF=6.37e-10 TR=0 TRB1=0 TRB2=0 TRC1=0 TRC2=0 TRE1=0 TRE2=0 TRM1=0 TRM2=0 VAF=100
+ VAR=0 VJC=0.75 VJE=0.75 VJS=0.75 VTF=0 XCJC=1 XTB=0 XTF=0 XTI=3 )
.ENDSYNTAX

.SYNTAX LTSPICE
.MODEL GENERATED_MODEL_QQ200 NPN( AF=0 BF=444 BR=3 CJC=2.5pf CJE=4pf CJS=0
+ EG=1.11 FC=0.5 IKF=25e-3 IKR=0 IRB=0 IS=1.43e-16 ISC=0 ISE=0 ISS=0 ITF=0 KF=0
+ MJC=0.33 MJE=0.33 MJS=0 NC=2 NE=1.5 NF=1 NR=1 NS=1 PTF=0 RB=0 RBM=0 RC=0 RE=0
+ TF=6.37e-10 TR=0 TRB1=0 TRB2=0 TRC1=0 TRC2=0 TRE1=0 TRE2=0 TRM1=0 TRM2=0 VAF=100
+ VAR=0 VJC=0.75 VJE=0.75 VJS=0.75 VTF=0 XCJC=1 XTB=0 XTF=0 XTI=3 )
.ENDSYNTAX

.SYNTAX LTSPICE
.MODEL GENERATED_MODEL_QQ203 NPN( AF=0 BF=444 BR=3 CJC=2.5pf CJE=4pf CJS=0
+ EG=1.11 FC=0.5 IKF=25e-3 IKR=0 IRB=0 IS=1.43e-16 ISC=0 ISE=0 ISS=0 ITF=0 KF=0
+ MJC=0.33 MJE=0.33 MJS=0 NC=2 NE=1.5 NF=1 NR=1 NS=1 PTF=0 RB=0 RBM=0 RC=0 RE=0
+ TF=6.37e-10 TR=0 TRB1=0 TRB2=0 TRC1=0 TRC2=0 TRE1=0 TRE2=0 TRM1=0 TRM2=0 VAF=100
+ VAR=0 VJC=0.75 VJE=0.75 VJS=0.75 VTF=0 XCJC=1 XTB=0 XTF=0 XTI=3 )
.ENDSYNTAX

.SYNTAX LTSPICE
.MODEL GENERATED_MODEL_QQ212 PNP( AF=0 BF=430 BR=3 CJC=2.5pf CJE=6pf CJS=0
+ EG=1.11 FC=0.5 IKF=25e-3 IKR=0 IRB=0 IS=1.43e-16 ISC=0 ISE=0 ISS=0 ITF=0 KF=0
+ MJC=0.33 MJE=0.33 MJS=0 NC=2 NE=1.5 NF=1 NR=1 NS=1 PTF=0 RB=0 RBM=0 RC=0 RE=0
+ TF=0 TR=0 TRB1=0 TRB2=0 TRC1=0 TRC2=0 TRE1=0 TRE2=0 TRM1=0 TRM2=0 VAF=50 VAR=0
+ VJC=0.75 VJE=0.75 VJS=0.75 VTF=0 XCJC=1 XTB=0 XTF=0 XTI=3 )
.ENDSYNTAX

.SYNTAX LTSPICE
.MODEL GENERATED_MODEL_QQ213 NPN( AF=0 BF=320 BR=1 CJC=3.7pf CJE=13pf CJS=0
+ EG=1.11 FC=0.5 IKF=12.5e-3 IKR=0 IRB=0 IS=6.58e-18 ISC=0 ISE=0 ISS=0 ITF=0 KF=0
+ MJC=0.33 MJE=0.33 MJS=0 NC=2 NE=1.5 NF=1 NR=1 NS=1 PTF=0 RB=0 RBM=0 RC=0 RE=0
+ TF=1.44e-9 TNOM=27 TR=0 TRB1=0 TRB2=0 TRC1=0 TRC2=0 TRE1=0 TRE2=0 TRM1=0 TRM2=0
+ VAF=150 VAR=0 VJC=0.75 VJE=0.75 VJS=0.75 VTF=0 XCJC=1 XTB=0 XTF=0 XTI=3 )
.ENDSYNTAX

.SYNTAX LTSPICE
.MODEL GENERATED_MODEL_QQ214 NPN( AF=0 BF=320 BR=1 CJC=3.7pf CJE=13pf CJS=0
+ EG=1.11 FC=0.5 IKF=12.5e-3 IKR=0 IRB=0 IS=6.58e-18 ISC=0 ISE=0 ISS=0 ITF=0 KF=0
+ MJC=0.33 MJE=0.33 MJS=0 NC=2 NE=1.5 NF=1 NR=1 NS=1 PTF=0 RB=0 RBM=0 RC=0 RE=0
+ TF=1.44e-9 TNOM=27 TR=0 TRB1=0 TRB2=0 TRC1=0 TRC2=0 TRE1=0 TRE2=0 TRM1=0 TRM2=0
+ VAF=150 VAR=0 VJC=0.75 VJE=0.75 VJS=0.75 VTF=0 XCJC=1 XTB=0 XTF=0 XTI=3 )
.ENDSYNTAX

.SYNTAX LTSPICE
.MODEL GENERATED_MODEL_QQ215 NPN( AF=0 BF=320 BR=1 CJC=3.7pf CJE=13pf CJS=0
+ EG=1.11 FC=0.5 IKF=12.5e-3 IKR=0 IRB=0 IS=6.58e-18 ISC=0 ISE=0 ISS=0 ITF=0 KF=0
+ MJC=0.33 MJE=0.33 MJS=0 NC=2 NE=1.5 NF=1 NR=1 NS=1 PTF=0 RB=0 RBM=0 RC=0 RE=0
+ TF=1.44e-9 TNOM=27 TR=0 TRB1=0 TRB2=0 TRC1=0 TRC2=0 TRE1=0 TRE2=0 TRM1=0 TRM2=0
+ VAF=150 VAR=0 VJC=0.75 VJE=0.75 VJS=0.75 VTF=0 XCJC=1 XTB=0 XTF=0 XTI=3 )
.ENDSYNTAX

.SYNTAX LTSPICE
.MODEL GENERATED_MODEL_QQ217 NPN( AF=0 BF=320 BR=1 CJC=3.7pf CJE=13pf CJS=0
+ EG=1.11 FC=0.5 IKF=12.5e-3 IKR=0 IRB=0 IS=6.58e-18 ISC=0 ISE=0 ISS=0 ITF=0 KF=0
+ MJC=0.33 MJE=0.33 MJS=0 NC=2 NE=1.5 NF=1 NR=1 NS=1 PTF=0 RB=0 RBM=0 RC=0 RE=0
+ TF=1.44e-9 TNOM=27 TR=0 TRB1=0 TRB2=0 TRC1=0 TRC2=0 TRE1=0 TRE2=0 TRM1=0 TRM2=0
+ VAF=150 VAR=0 VJC=0.75 VJE=0.75 VJS=0.75 VTF=0 XCJC=1 XTB=0 XTF=0 XTI=3 )
.ENDSYNTAX

.SYNTAX LTSPICE
.MODEL GENERATED_MODEL_QQ219 NPN( AF=0 BF=320 BR=1 CJC=3.7pf CJE=13pf CJS=0
+ EG=1.11 FC=0.5 IKF=12.5e-3 IKR=0 IRB=0 IS=6.58e-18 ISC=0 ISE=0 ISS=0 ITF=0 KF=0
+ MJC=0.33 MJE=0.33 MJS=0 NC=2 NE=1.5 NF=1 NR=1 NS=1 PTF=0 RB=0 RBM=0 RC=0 RE=0
+ TF=1.44e-9 TNOM=27 TR=0 TRB1=0 TRB2=0 TRC1=0 TRC2=0 TRE1=0 TRE2=0 TRM1=0 TRM2=0
+ VAF=150 VAR=0 VJC=0.75 VJE=0.75 VJS=0.75 VTF=0 XCJC=1 XTB=0 XTF=0 XTI=3 )
.ENDSYNTAX

.SYNTAX LTSPICE
.MODEL GENERATED_MODEL_QQ220 NPN( AF=0 BF=320 BR=1 CJC=3.7pf CJE=13pf CJS=0
+ EG=1.11 FC=0.5 IKF=12.5e-3 IKR=0 IRB=0 IS=6.58e-18 ISC=0 ISE=0 ISS=0 ITF=0 KF=0
+ MJC=0.33 MJE=0.33 MJS=0 NC=2 NE=1.5 NF=1 NR=1 NS=1 PTF=0 RB=0 RBM=0 RC=0 RE=0
+ TF=1.44e-9 TNOM=27 TR=0 TRB1=0 TRB2=0 TRC1=0 TRC2=0 TRE1=0 TRE2=0 TRM1=0 TRM2=0
+ VAF=150 VAR=0 VJC=0.75 VJE=0.75 VJS=0.75 VTF=0 XCJC=1 XTB=0 XTF=0 XTI=3 )
.ENDSYNTAX

.SYNTAX LTSPICE
.MODEL GENERATED_MODEL_QQ221 NPN( AF=0 BF=320 BR=1 CJC=3.7pf CJE=13pf CJS=0
+ EG=1.11 FC=0.5 IKF=12.5e-3 IKR=0 IRB=0 IS=6.58e-18 ISC=0 ISE=0 ISS=0 ITF=0 KF=0
+ MJC=0.33 MJE=0.33 MJS=0 NC=2 NE=1.5 NF=1 NR=1 NS=1 PTF=0 RB=0 RBM=0 RC=0 RE=0
+ TF=1.44e-9 TNOM=27 TR=0 TRB1=0 TRB2=0 TRC1=0 TRC2=0 TRE1=0 TRE2=0 TRM1=0 TRM2=0
+ VAF=150 VAR=0 VJC=0.75 VJE=0.75 VJS=0.75 VTF=0 XCJC=1 XTB=0 XTF=0 XTI=3 )
.ENDSYNTAX

.SYNTAX LTSPICE
.MODEL GENERATED_MODEL_QQ223 NPN( AF=0 BF=320 BR=1 CJC=3.7pf CJE=13pf CJS=0
+ EG=1.11 FC=0.5 IKF=12.5e-3 IKR=0 IRB=0 IS=6.58e-18 ISC=0 ISE=0 ISS=0 ITF=0 KF=0
+ MJC=0.33 MJE=0.33 MJS=0 NC=2 NE=1.5 NF=1 NR=1 NS=1 PTF=0 RB=0 RBM=0 RC=0 RE=0
+ TF=1.44e-9 TNOM=27 TR=0 TRB1=0 TRB2=0 TRC1=0 TRC2=0 TRE1=0 TRE2=0 TRM1=0 TRM2=0
+ VAF=150 VAR=0 VJC=0.75 VJE=0.75 VJS=0.75 VTF=0 XCJC=1 XTB=0 XTF=0 XTI=3 )
.ENDSYNTAX

.SYNTAX LTSPICE
.MODEL GENERATED_MODEL_QQ224 NPN( AF=0 BF=320 BR=1 CJC=3.7pf CJE=13pf CJS=0
+ EG=1.11 FC=0.5 IKF=12.5e-3 IKR=0 IRB=0 IS=6.58e-18 ISC=0 ISE=0 ISS=0 ITF=0 KF=0
+ MJC=0.33 MJE=0.33 MJS=0 NC=2 NE=1.5 NF=1 NR=1 NS=1 PTF=0 RB=0 RBM=0 RC=0 RE=0
+ TF=1.44e-9 TNOM=27 TR=0 TRB1=0 TRB2=0 TRC1=0 TRC2=0 TRE1=0 TRE2=0 TRM1=0 TRM2=0
+ VAF=150 VAR=0 VJC=0.75 VJE=0.75 VJS=0.75 VTF=0 XCJC=1 XTB=0 XTF=0 XTI=3 )
.ENDSYNTAX

.SYNTAX LTSPICE
.MODEL GENERATED_MODEL_QQ225 NPN( AF=0 BF=320 BR=1 CJC=3.7pf CJE=13pf CJS=0
+ EG=1.11 FC=0.5 IKF=12.5e-3 IKR=0 IRB=0 IS=6.58e-18 ISC=0 ISE=0 ISS=0 ITF=0 KF=0
+ MJC=0.33 MJE=0.33 MJS=0 NC=2 NE=1.5 NF=1 NR=1 NS=1 PTF=0 RB=0 RBM=0 RC=0 RE=0
+ TF=1.44e-9 TNOM=27 TR=0 TRB1=0 TRB2=0 TRC1=0 TRC2=0 TRE1=0 TRE2=0 TRM1=0 TRM2=0
+ VAF=150 VAR=0 VJC=0.75 VJE=0.75 VJS=0.75 VTF=0 XCJC=1 XTB=0 XTF=0 XTI=3 )
.ENDSYNTAX

.SYNTAX LTSPICE
.MODEL GENERATED_MODEL_QQ226 NPN( AF=0 BF=320 BR=1 CJC=3.7pf CJE=13pf CJS=0
+ EG=1.11 FC=0.5 IKF=12.5e-3 IKR=0 IRB=0 IS=6.58e-18 ISC=0 ISE=0 ISS=0 ITF=0 KF=0
+ MJC=0.33 MJE=0.33 MJS=0 NC=2 NE=1.5 NF=1 NR=1 NS=1 PTF=0 RB=0 RBM=0 RC=0 RE=0
+ TF=1.44e-9 TNOM=27 TR=0 TRB1=0 TRB2=0 TRC1=0 TRC2=0 TRE1=0 TRE2=0 TRM1=0 TRM2=0
+ VAF=150 VAR=0 VJC=0.75 VJE=0.75 VJS=0.75 VTF=0 XCJC=1 XTB=0 XTF=0 XTI=3 )
.ENDSYNTAX

.SYNTAX LTSPICE
.MODEL GENERATED_MODEL_QQ227 NPN( AF=0 BF=444 BR=3 CJC=2.5pf CJE=4pf CJS=0
+ EG=1.11 FC=0.5 IKF=25e-3 IKR=0 IRB=0 IS=1.43e-16 ISC=0 ISE=0 ISS=0 ITF=0 KF=0
+ MJC=0.33 MJE=0.33 MJS=0 NC=2 NE=1.5 NF=1 NR=1 NS=1 PTF=0 RB=0 RBM=0 RC=0 RE=0
+ TF=6.37e-10 TR=0 TRB1=0 TRB2=0 TRC1=0 TRC2=0 TRE1=0 TRE2=0 TRM1=0 TRM2=0 VAF=100
+ VAR=0 VJC=0.75 VJE=0.75 VJS=0.75 VTF=0 XCJC=1 XTB=0 XTF=0 XTI=3 )
.ENDSYNTAX

.SYNTAX LTSPICE
.MODEL GENERATED_MODEL_QQ228 NPN( AF=0 BF=320 BR=1 CJC=3.7pf CJE=13pf CJS=0
+ EG=1.11 FC=0.5 IKF=12.5e-3 IKR=0 IRB=0 IS=6.58e-18 ISC=0 ISE=0 ISS=0 ITF=0 KF=0
+ MJC=0.33 MJE=0.33 MJS=0 NC=2 NE=1.5 NF=1 NR=1 NS=1 PTF=0 RB=0 RBM=0 RC=0 RE=0
+ TF=1.44e-9 TNOM=27 TR=0 TRB1=0 TRB2=0 TRC1=0 TRC2=0 TRE1=0 TRE2=0 TRM1=0 TRM2=0
+ VAF=150 VAR=0 VJC=0.75 VJE=0.75 VJS=0.75 VTF=0 XCJC=1 XTB=0 XTF=0 XTI=3 )
.ENDSYNTAX

.SYNTAX LTSPICE
.MODEL GENERATED_MODEL_QQ229 NPN( AF=0 BF=320 BR=1 CJC=3.7pf CJE=13pf CJS=0
+ EG=1.11 FC=0.5 IKF=12.5e-3 IKR=0 IRB=0 IS=6.58e-18 ISC=0 ISE=0 ISS=0 ITF=0 KF=0
+ MJC=0.33 MJE=0.33 MJS=0 NC=2 NE=1.5 NF=1 NR=1 NS=1 PTF=0 RB=0 RBM=0 RC=0 RE=0
+ TF=1.44e-9 TNOM=27 TR=0 TRB1=0 TRB2=0 TRC1=0 TRC2=0 TRE1=0 TRE2=0 TRM1=0 TRM2=0
+ VAF=150 VAR=0 VJC=0.75 VJE=0.75 VJS=0.75 VTF=0 XCJC=1 XTB=0 XTF=0 XTI=3 )
.ENDSYNTAX

.SYNTAX LTSPICE
.MODEL GENERATED_MODEL_QQ231 NPN( AF=0 BF=320 BR=1 CJC=3.7pf CJE=13pf CJS=0
+ EG=1.11 FC=0.5 IKF=12.5e-3 IKR=0 IRB=0 IS=6.58e-18 ISC=0 ISE=0 ISS=0 ITF=0 KF=0
+ MJC=0.33 MJE=0.33 MJS=0 NC=2 NE=1.5 NF=1 NR=1 NS=1 PTF=0 RB=0 RBM=0 RC=0 RE=0
+ TF=1.44e-9 TNOM=27 TR=0 TRB1=0 TRB2=0 TRC1=0 TRC2=0 TRE1=0 TRE2=0 TRM1=0 TRM2=0
+ VAF=150 VAR=0 VJC=0.75 VJE=0.75 VJS=0.75 VTF=0 XCJC=1 XTB=0 XTF=0 XTI=3 )
.ENDSYNTAX

.SYNTAX LTSPICE
.MODEL GENERATED_MODEL_QQ233 NPN( AF=0 BF=320 BR=1 CJC=3.7pf CJE=13pf CJS=0
+ EG=1.11 FC=0.5 IKF=12.5e-3 IKR=0 IRB=0 IS=6.58e-18 ISC=0 ISE=0 ISS=0 ITF=0 KF=0
+ MJC=0.33 MJE=0.33 MJS=0 NC=2 NE=1.5 NF=1 NR=1 NS=1 PTF=0 RB=0 RBM=0 RC=0 RE=0
+ TF=1.44e-9 TNOM=27 TR=0 TRB1=0 TRB2=0 TRC1=0 TRC2=0 TRE1=0 TRE2=0 TRM1=0 TRM2=0
+ VAF=150 VAR=0 VJC=0.75 VJE=0.75 VJS=0.75 VTF=0 XCJC=1 XTB=0 XTF=0 XTI=3 )
.ENDSYNTAX

.SYNTAX LTSPICE
.MODEL GENERATED_MODEL_QQ234 NPN( AF=0 BF=320 BR=1 CJC=3.7pf CJE=13pf CJS=0
+ EG=1.11 FC=0.5 IKF=12.5e-3 IKR=0 IRB=0 IS=6.58e-18 ISC=0 ISE=0 ISS=0 ITF=0 KF=0
+ MJC=0.33 MJE=0.33 MJS=0 NC=2 NE=1.5 NF=1 NR=1 NS=1 PTF=0 RB=0 RBM=0 RC=0 RE=0
+ TF=1.44e-9 TNOM=27 TR=0 TRB1=0 TRB2=0 TRC1=0 TRC2=0 TRE1=0 TRE2=0 TRM1=0 TRM2=0
+ VAF=150 VAR=0 VJC=0.75 VJE=0.75 VJS=0.75 VTF=0 XCJC=1 XTB=0 XTF=0 XTI=3 )
.ENDSYNTAX

.SYNTAX LTSPICE
.MODEL GENERATED_MODEL_QQ238 NPN( AF=0 BF=320 BR=1 CJC=3.7pf CJE=13pf CJS=0
+ EG=1.11 FC=0.5 IKF=12.5e-3 IKR=0 IRB=0 IS=6.58e-18 ISC=0 ISE=0 ISS=0 ITF=0 KF=0
+ MJC=0.33 MJE=0.33 MJS=0 NC=2 NE=1.5 NF=1 NR=1 NS=1 PTF=0 RB=0 RBM=0 RC=0 RE=0
+ TF=1.44e-9 TNOM=27 TR=0 TRB1=0 TRB2=0 TRC1=0 TRC2=0 TRE1=0 TRE2=0 TRM1=0 TRM2=0
+ VAF=150 VAR=0 VJC=0.75 VJE=0.75 VJS=0.75 VTF=0 XCJC=1 XTB=0 XTF=0 XTI=3 )
.ENDSYNTAX

.SYNTAX LTSPICE
.MODEL GENERATED_MODEL_QQ240 NPN( AF=0 BF=320 BR=1 CJC=3.7pf CJE=13pf CJS=0
+ EG=1.11 FC=0.5 IKF=12.5e-3 IKR=0 IRB=0 IS=6.58e-18 ISC=0 ISE=0 ISS=0 ITF=0 KF=0
+ MJC=0.33 MJE=0.33 MJS=0 NC=2 NE=1.5 NF=1 NR=1 NS=1 PTF=0 RB=0 RBM=0 RC=0 RE=0
+ TF=1.44e-9 TNOM=27 TR=0 TRB1=0 TRB2=0 TRC1=0 TRC2=0 TRE1=0 TRE2=0 TRM1=0 TRM2=0
+ VAF=150 VAR=0 VJC=0.75 VJE=0.75 VJS=0.75 VTF=0 XCJC=1 XTB=0 XTF=0 XTI=3 )
.ENDSYNTAX

.SYNTAX LTSPICE
.MODEL GENERATED_MODEL_QQ242 NPN( AF=0 BF=320 BR=1 CJC=3.7pf CJE=13pf CJS=0
+ EG=1.11 FC=0.5 IKF=12.5e-3 IKR=0 IRB=0 IS=6.58e-18 ISC=0 ISE=0 ISS=0 ITF=0 KF=0
+ MJC=0.33 MJE=0.33 MJS=0 NC=2 NE=1.5 NF=1 NR=1 NS=1 PTF=0 RB=0 RBM=0 RC=0 RE=0
+ TF=1.44e-9 TNOM=27 TR=0 TRB1=0 TRB2=0 TRC1=0 TRC2=0 TRE1=0 TRE2=0 TRM1=0 TRM2=0
+ VAF=150 VAR=0 VJC=0.75 VJE=0.75 VJS=0.75 VTF=0 XCJC=1 XTB=0 XTF=0 XTI=3 )
.ENDSYNTAX

.SYNTAX LTSPICE
.MODEL GENERATED_MODEL_QQ243 NPN( AF=0 BF=320 BR=1 CJC=3.7pf CJE=13pf CJS=0
+ EG=1.11 FC=0.5 IKF=12.5e-3 IKR=0 IRB=0 IS=6.58e-18 ISC=0 ISE=0 ISS=0 ITF=0 KF=0
+ MJC=0.33 MJE=0.33 MJS=0 NC=2 NE=1.5 NF=1 NR=1 NS=1 PTF=0 RB=0 RBM=0 RC=0 RE=0
+ TF=1.44e-9 TNOM=27 TR=0 TRB1=0 TRB2=0 TRC1=0 TRC2=0 TRE1=0 TRE2=0 TRM1=0 TRM2=0
+ VAF=150 VAR=0 VJC=0.75 VJE=0.75 VJS=0.75 VTF=0 XCJC=1 XTB=0 XTF=0 XTI=3 )
.ENDSYNTAX

.SYNTAX LTSPICE
.MODEL GENERATED_MODEL_QQ245 NPN( AF=0 BF=320 BR=1 CJC=3.7pf CJE=13pf CJS=0
+ EG=1.11 FC=0.5 IKF=12.5e-3 IKR=0 IRB=0 IS=6.58e-18 ISC=0 ISE=0 ISS=0 ITF=0 KF=0
+ MJC=0.33 MJE=0.33 MJS=0 NC=2 NE=1.5 NF=1 NR=1 NS=1 PTF=0 RB=0 RBM=0 RC=0 RE=0
+ TF=1.44e-9 TNOM=27 TR=0 TRB1=0 TRB2=0 TRC1=0 TRC2=0 TRE1=0 TRE2=0 TRM1=0 TRM2=0
+ VAF=150 VAR=0 VJC=0.75 VJE=0.75 VJS=0.75 VTF=0 XCJC=1 XTB=0 XTF=0 XTI=3 )
.ENDSYNTAX

.SYNTAX LTSPICE
.MODEL GENERATED_MODEL_QQ246 NPN( AF=0 BF=320 BR=1 CJC=3.7pf CJE=13pf CJS=0
+ EG=1.11 FC=0.5 IKF=12.5e-3 IKR=0 IRB=0 IS=6.58e-18 ISC=0 ISE=0 ISS=0 ITF=0 KF=0
+ MJC=0.33 MJE=0.33 MJS=0 NC=2 NE=1.5 NF=1 NR=1 NS=1 PTF=0 RB=0 RBM=0 RC=0 RE=0
+ TF=1.44e-9 TNOM=27 TR=0 TRB1=0 TRB2=0 TRC1=0 TRC2=0 TRE1=0 TRE2=0 TRM1=0 TRM2=0
+ VAF=150 VAR=0 VJC=0.75 VJE=0.75 VJS=0.75 VTF=0 XCJC=1 XTB=0 XTF=0 XTI=3 )
.ENDSYNTAX

.SYNTAX LTSPICE
.MODEL GENERATED_MODEL_QQ247 NPN( AF=0 BF=320 BR=1 CJC=3.7pf CJE=13pf CJS=0
+ EG=1.11 FC=0.5 IKF=12.5e-3 IKR=0 IRB=0 IS=6.58e-18 ISC=0 ISE=0 ISS=0 ITF=0 KF=0
+ MJC=0.33 MJE=0.33 MJS=0 NC=2 NE=1.5 NF=1 NR=1 NS=1 PTF=0 RB=0 RBM=0 RC=0 RE=0
+ TF=1.44e-9 TNOM=27 TR=0 TRB1=0 TRB2=0 TRC1=0 TRC2=0 TRE1=0 TRE2=0 TRM1=0 TRM2=0
+ VAF=150 VAR=0 VJC=0.75 VJE=0.75 VJS=0.75 VTF=0 XCJC=1 XTB=0 XTF=0 XTI=3 )
.ENDSYNTAX

.SYNTAX LTSPICE
.MODEL GENERATED_MODEL_QQ248 NPN( AF=0 BF=320 BR=1 CJC=3.7pf CJE=13pf CJS=0
+ EG=1.11 FC=0.5 IKF=12.5e-3 IKR=0 IRB=0 IS=6.58e-18 ISC=0 ISE=0 ISS=0 ITF=0 KF=0
+ MJC=0.33 MJE=0.33 MJS=0 NC=2 NE=1.5 NF=1 NR=1 NS=1 PTF=0 RB=0 RBM=0 RC=0 RE=0
+ TF=1.44e-9 TNOM=27 TR=0 TRB1=0 TRB2=0 TRC1=0 TRC2=0 TRE1=0 TRE2=0 TRM1=0 TRM2=0
+ VAF=150 VAR=0 VJC=0.75 VJE=0.75 VJS=0.75 VTF=0 XCJC=1 XTB=0 XTF=0 XTI=3 )
.ENDSYNTAX

.SYNTAX LTSPICE
.MODEL GENERATED_MODEL_QQ251 PNP( AF=0 BF=430 BR=3 CJC=2.5pf CJE=6pf CJS=0
+ EG=1.11 FC=0.5 IKF=25e-3 IKR=0 IRB=0 IS=1.43e-16 ISC=0 ISE=0 ISS=0 ITF=0 KF=0
+ MJC=0.33 MJE=0.33 MJS=0 NC=2 NE=1.5 NF=1 NR=1 NS=1 PTF=0 RB=0 RBM=0 RC=0 RE=0
+ TF=0 TR=0 TRB1=0 TRB2=0 TRC1=0 TRC2=0 TRE1=0 TRE2=0 TRM1=0 TRM2=0 VAF=50 VAR=0
+ VJC=0.75 VJE=0.75 VJS=0.75 VTF=0 XCJC=1 XTB=0 XTF=0 XTI=3 )
.ENDSYNTAX

.SYNTAX LTSPICE
.MODEL GENERATED_MODEL_QQ252 PNP( AF=0 BF=430 BR=3 CJC=2.5pf CJE=6pf CJS=0
+ EG=1.11 FC=0.5 IKF=25e-3 IKR=0 IRB=0 IS=1.43e-16 ISC=0 ISE=0 ISS=0 ITF=0 KF=0
+ MJC=0.33 MJE=0.33 MJS=0 NC=2 NE=1.5 NF=1 NR=1 NS=1 PTF=0 RB=0 RBM=0 RC=0 RE=0
+ TF=0 TR=0 TRB1=0 TRB2=0 TRC1=0 TRC2=0 TRE1=0 TRE2=0 TRM1=0 TRM2=0 VAF=50 VAR=0
+ VJC=0.75 VJE=0.75 VJS=0.75 VTF=0 XCJC=1 XTB=0 XTF=0 XTI=3 )
.ENDSYNTAX

.SYNTAX LTSPICE
.MODEL GENERATED_MODEL_QQ254 PNP( AF=0 BF=430 BR=3 CJC=2.5pf CJE=6pf CJS=0
+ EG=1.11 FC=0.5 IKF=25e-3 IKR=0 IRB=0 IS=1.43e-16 ISC=0 ISE=0 ISS=0 ITF=0 KF=0
+ MJC=0.33 MJE=0.33 MJS=0 NC=2 NE=1.5 NF=1 NR=1 NS=1 PTF=0 RB=0 RBM=0 RC=0 RE=0
+ TF=0 TR=0 TRB1=0 TRB2=0 TRC1=0 TRC2=0 TRE1=0 TRE2=0 TRM1=0 TRM2=0 VAF=50 VAR=0
+ VJC=0.75 VJE=0.75 VJS=0.75 VTF=0 XCJC=1 XTB=0 XTF=0 XTI=3 )
.ENDSYNTAX

.SYNTAX LTSPICE
.MODEL GENERATED_MODEL_QQ255 PNP( AF=0 BF=430 BR=3 CJC=2.5pf CJE=6pf CJS=0
+ EG=1.11 FC=0.5 IKF=25e-3 IKR=0 IRB=0 IS=1.43e-16 ISC=0 ISE=0 ISS=0 ITF=0 KF=0
+ MJC=0.33 MJE=0.33 MJS=0 NC=2 NE=1.5 NF=1 NR=1 NS=1 PTF=0 RB=0 RBM=0 RC=0 RE=0
+ TF=0 TR=0 TRB1=0 TRB2=0 TRC1=0 TRC2=0 TRE1=0 TRE2=0 TRM1=0 TRM2=0 VAF=50 VAR=0
+ VJC=0.75 VJE=0.75 VJS=0.75 VTF=0 XCJC=1 XTB=0 XTF=0 XTI=3 )
.ENDSYNTAX

.SYNTAX LTSPICE
.MODEL GENERATED_MODEL_QQ257 PNP( AF=0 BF=430 BR=3 CJC=2.5pf CJE=6pf CJS=0
+ EG=1.11 FC=0.5 IKF=25e-3 IKR=0 IRB=0 IS=1.43e-16 ISC=0 ISE=0 ISS=0 ITF=0 KF=0
+ MJC=0.33 MJE=0.33 MJS=0 NC=2 NE=1.5 NF=1 NR=1 NS=1 PTF=0 RB=0 RBM=0 RC=0 RE=0
+ TF=0 TR=0 TRB1=0 TRB2=0 TRC1=0 TRC2=0 TRE1=0 TRE2=0 TRM1=0 TRM2=0 VAF=50 VAR=0
+ VJC=0.75 VJE=0.75 VJS=0.75 VTF=0 XCJC=1 XTB=0 XTF=0 XTI=3 )
.ENDSYNTAX

.SYNTAX LTSPICE
.MODEL GENERATED_MODEL_QQ258 PNP( AF=0 BF=430 BR=3 CJC=2.5pf CJE=6pf CJS=0
+ EG=1.11 FC=0.5 IKF=25e-3 IKR=0 IRB=0 IS=1.43e-16 ISC=0 ISE=0 ISS=0 ITF=0 KF=0
+ MJC=0.33 MJE=0.33 MJS=0 NC=2 NE=1.5 NF=1 NR=1 NS=1 PTF=0 RB=0 RBM=0 RC=0 RE=0
+ TF=0 TR=0 TRB1=0 TRB2=0 TRC1=0 TRC2=0 TRE1=0 TRE2=0 TRM1=0 TRM2=0 VAF=50 VAR=0
+ VJC=0.75 VJE=0.75 VJS=0.75 VTF=0 XCJC=1 XTB=0 XTF=0 XTI=3 )
.ENDSYNTAX

.SYNTAX LTSPICE
.MODEL GENERATED_MODEL_QQ261 NPN( AF=0 BF=320 BR=1 CJC=3.7pf CJE=13pf CJS=0
+ EG=1.11 FC=0.5 IKF=12.5e-3 IKR=0 IRB=0 IS=6.58e-18 ISC=0 ISE=0 ISS=0 ITF=0 KF=0
+ MJC=0.33 MJE=0.33 MJS=0 NC=2 NE=1.5 NF=1 NR=1 NS=1 PTF=0 RB=0 RBM=0 RC=0 RE=0
+ TF=1.44e-9 TNOM=27 TR=0 TRB1=0 TRB2=0 TRC1=0 TRC2=0 TRE1=0 TRE2=0 TRM1=0 TRM2=0
+ VAF=150 VAR=0 VJC=0.75 VJE=0.75 VJS=0.75 VTF=0 XCJC=1 XTB=0 XTF=0 XTI=3 )
.ENDSYNTAX

.SYNTAX LTSPICE
.MODEL GENERATED_MODEL_QQ262 NPN( AF=0 BF=320 BR=1 CJC=3.7pf CJE=13pf CJS=0
+ EG=1.11 FC=0.5 IKF=12.5e-3 IKR=0 IRB=0 IS=6.58e-18 ISC=0 ISE=0 ISS=0 ITF=0 KF=0
+ MJC=0.33 MJE=0.33 MJS=0 NC=2 NE=1.5 NF=1 NR=1 NS=1 PTF=0 RB=0 RBM=0 RC=0 RE=0
+ TF=1.44e-9 TNOM=27 TR=0 TRB1=0 TRB2=0 TRC1=0 TRC2=0 TRE1=0 TRE2=0 TRM1=0 TRM2=0
+ VAF=150 VAR=0 VJC=0.75 VJE=0.75 VJS=0.75 VTF=0 XCJC=1 XTB=0 XTF=0 XTI=3 )
.ENDSYNTAX

.SYNTAX LTSPICE
.MODEL GENERATED_MODEL_QQ264 NPN( AF=0 BF=320 BR=1 CJC=3.7pf CJE=13pf CJS=0
+ EG=1.11 FC=0.5 IKF=12.5e-3 IKR=0 IRB=0 IS=6.58e-18 ISC=0 ISE=0 ISS=0 ITF=0 KF=0
+ MJC=0.33 MJE=0.33 MJS=0 NC=2 NE=1.5 NF=1 NR=1 NS=1 PTF=0 RB=0 RBM=0 RC=0 RE=0
+ TF=1.44e-9 TNOM=27 TR=0 TRB1=0 TRB2=0 TRC1=0 TRC2=0 TRE1=0 TRE2=0 TRM1=0 TRM2=0
+ VAF=150 VAR=0 VJC=0.75 VJE=0.75 VJS=0.75 VTF=0 XCJC=1 XTB=0 XTF=0 XTI=3 )
.ENDSYNTAX

.SYNTAX LTSPICE
.MODEL GENERATED_MODEL_QQ265 NPN( AF=0 BF=320 BR=1 CJC=3.7pf CJE=13pf CJS=0
+ EG=1.11 FC=0.5 IKF=12.5e-3 IKR=0 IRB=0 IS=6.58e-18 ISC=0 ISE=0 ISS=0 ITF=0 KF=0
+ MJC=0.33 MJE=0.33 MJS=0 NC=2 NE=1.5 NF=1 NR=1 NS=1 PTF=0 RB=0 RBM=0 RC=0 RE=0
+ TF=1.44e-9 TNOM=27 TR=0 TRB1=0 TRB2=0 TRC1=0 TRC2=0 TRE1=0 TRE2=0 TRM1=0 TRM2=0
+ VAF=150 VAR=0 VJC=0.75 VJE=0.75 VJS=0.75 VTF=0 XCJC=1 XTB=0 XTF=0 XTI=3 )
.ENDSYNTAX

.SYNTAX LTSPICE
.MODEL GENERATED_MODEL_QQ274 PNP( AF=0 BF=310 BR=1 CJC=3pf CJE=20pf CJS=0 EG=1.11
+ FC=0.5 IKF=12.5e-3 IKR=0 IRB=0 IS=6.58e-18 ISC=0 ISE=0 ISS=0 ITF=0 MJC=0.33
+ MJE=0.33 MJS=0 NC=2 NE=1.5 NF=1 NR=1 NS=1 PTF=0 RB=0 RBM=0 RC=0 RE=0 TF=1.59e-9
+ TR=0 TRB1=0 TRB2=0 TRC1=0 TRC2=0 TRE1=0 TRE2=0 TRM1=0 TRM2=0 VAF=100 VAR=0
+ VJC=0.75 VJE=0.75 VJS=0.75 VTF=0 XCJC=1 XTB=0 XTF=0 XTI=3 )
.ENDSYNTAX

.SYNTAX LTSPICE
.MODEL GENERATED_MODEL_QQ275 PNP( AF=0 BF=310 BR=1 CJC=3pf CJE=20pf CJS=0 EG=1.11
+ FC=0.5 IKF=12.5e-3 IKR=0 IRB=0 IS=6.58e-18 ISC=0 ISE=0 ISS=0 ITF=0 MJC=0.33
+ MJE=0.33 MJS=0 NC=2 NE=1.5 NF=1 NR=1 NS=1 PTF=0 RB=0 RBM=0 RC=0 RE=0 TF=1.59e-9
+ TR=0 TRB1=0 TRB2=0 TRC1=0 TRC2=0 TRE1=0 TRE2=0 TRM1=0 TRM2=0 VAF=100 VAR=0
+ VJC=0.75 VJE=0.75 VJS=0.75 VTF=0 XCJC=1 XTB=0 XTF=0 XTI=3 )
.ENDSYNTAX

.SYNTAX LTSPICE
.MODEL GENERATED_MODEL_QQ279 PNP( AF=0 BF=430 BR=3 CJC=2.5pf CJE=6pf CJS=0
+ EG=1.11 FC=0.5 IKF=25e-3 IKR=0 IRB=0 IS=1.43e-16 ISC=0 ISE=0 ISS=0 ITF=0 KF=0
+ MJC=0.33 MJE=0.33 MJS=0 NC=2 NE=1.5 NF=1 NR=1 NS=1 PTF=0 RB=0 RBM=0 RC=0 RE=0
+ TF=0 TR=0 TRB1=0 TRB2=0 TRC1=0 TRC2=0 TRE1=0 TRE2=0 TRM1=0 TRM2=0 VAF=50 VAR=0
+ VJC=0.75 VJE=0.75 VJS=0.75 VTF=0 XCJC=1 XTB=0 XTF=0 XTI=3 )
.ENDSYNTAX

.SYNTAX LTSPICE
.MODEL GENERATED_MODEL_QQ283 PNP( AF=0 BF=310 BR=1 CJC=3pf CJE=20pf CJS=0 EG=1.11
+ FC=0.5 IKF=12.5e-3 IKR=0 IRB=0 IS=6.58e-18 ISC=0 ISE=0 ISS=0 ITF=0 MJC=0.33
+ MJE=0.33 MJS=0 NC=2 NE=1.5 NF=1 NR=1 NS=1 PTF=0 RB=0 RBM=0 RC=0 RE=0 TF=1.59e-9
+ TR=0 TRB1=0 TRB2=0 TRC1=0 TRC2=0 TRE1=0 TRE2=0 TRM1=0 TRM2=0 VAF=100 VAR=0
+ VJC=0.75 VJE=0.75 VJS=0.75 VTF=0 XCJC=1 XTB=0 XTF=0 XTI=3 )
.ENDSYNTAX

.SYNTAX LTSPICE
.MODEL GENERATED_MODEL_QQ288 PNP( AF=0 BF=310 BR=1 CJC=3pf CJE=20pf CJS=0 EG=1.11
+ FC=0.5 IKF=12.5e-3 IKR=0 IRB=0 IS=6.58e-18 ISC=0 ISE=0 ISS=0 ITF=0 MJC=0.33
+ MJE=0.33 MJS=0 NC=2 NE=1.5 NF=1 NR=1 NS=1 PTF=0 RB=0 RBM=0 RC=0 RE=0 TF=1.59e-9
+ TR=0 TRB1=0 TRB2=0 TRC1=0 TRC2=0 TRE1=0 TRE2=0 TRM1=0 TRM2=0 VAF=100 VAR=0
+ VJC=0.75 VJE=0.75 VJS=0.75 VTF=0 XCJC=1 XTB=0 XTF=0 XTI=3 )
.ENDSYNTAX

.SYNTAX LTSPICE
.MODEL GENERATED_MODEL_QQ289 NPN( AF=0 BF=320 BR=1 CJC=3.7pf CJE=13pf CJS=0
+ EG=1.11 FC=0.5 IKF=12.5e-3 IKR=0 IRB=0 IS=6.58e-18 ISC=0 ISE=0 ISS=0 ITF=0 KF=0
+ MJC=0.33 MJE=0.33 MJS=0 NC=2 NE=1.5 NF=1 NR=1 NS=1 PTF=0 RB=0 RBM=0 RC=0 RE=0
+ TF=1.44e-9 TNOM=27 TR=0 TRB1=0 TRB2=0 TRC1=0 TRC2=0 TRE1=0 TRE2=0 TRM1=0 TRM2=0
+ VAF=150 VAR=0 VJC=0.75 VJE=0.75 VJS=0.75 VTF=0 XCJC=1 XTB=0 XTF=0 XTI=3 )
.ENDSYNTAX

.SYNTAX LTSPICE
.MODEL GENERATED_MODEL_QQ292 NPN( AF=0 BF=320 BR=1 CJC=3.7pf CJE=13pf CJS=0
+ EG=1.11 FC=0.5 IKF=12.5e-3 IKR=0 IRB=0 IS=6.58e-18 ISC=0 ISE=0 ISS=0 ITF=0 KF=0
+ MJC=0.33 MJE=0.33 MJS=0 NC=2 NE=1.5 NF=1 NR=1 NS=1 PTF=0 RB=0 RBM=0 RC=0 RE=0
+ TF=1.44e-9 TNOM=27 TR=0 TRB1=0 TRB2=0 TRC1=0 TRC2=0 TRE1=0 TRE2=0 TRM1=0 TRM2=0
+ VAF=150 VAR=0 VJC=0.75 VJE=0.75 VJS=0.75 VTF=0 XCJC=1 XTB=0 XTF=0 XTI=3 )
.ENDSYNTAX

.SYNTAX LTSPICE
.model PNP_Mod_Gummel_Poon pnp(level=2)
.ENDSYNTAX

.SYNTAX LTSPICE
*---------------------------------------------
* Modified Version of the Gummel-Poon Model - like LTSPICE and PSPICE model
.model NPN_Mod_Gummel_Poon npn(level=2)
.ENDSYNTAX

.END
